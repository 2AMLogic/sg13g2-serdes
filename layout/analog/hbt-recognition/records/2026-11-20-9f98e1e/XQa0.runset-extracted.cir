* Extracted by KLayout with SG13G2 LVS runset on : 20/11/2026 23:10

.SUBCKT ctle_XQa0
Q$1 \$4 \$2 \$3 \$1 npn13G2 we=70n le=900n Nx=1 m=1
.ENDS ctle_XQa0
