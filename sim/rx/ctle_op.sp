* CTLE sizing bench (issue #22): 8 copies of ctle, one per peaking code,
* driven by the same ideal differential source. Sizing evidence, not a spec result.
* vcm and the control levels track the supply (vcm = 0.7917 vdd; control
* high = vdd, low = vdd - 0.25 V). Output load is a 80 fF placeholder per side
* (stand-in for the four latch inputs; replaced by extraction in #24/#28).
.include ../../design/rx/netlists/ctle.spice
Vdd vdd 0 1.2
Bvcm vcm 0 V=0.7917*v(vdd)
Vip inp vcm dc 0
Vin inn vcm dc 0
Bk0_0 c0k0 0 V=v(vdd)-0.25
Bk0_0b c0k0b 0 V=v(vdd)
Bk0_1 c0k1 0 V=v(vdd)-0.25
Bk0_1b c0k1b 0 V=v(vdd)
Bk0_2 c0k2 0 V=v(vdd)-0.25
Bk0_2b c0k2b 0 V=v(vdd)
Xd0 inp inn vcm vdd 0 c0k0 c0k0b c0k1 c0k1b c0k2 c0k2b op0 on0 ctle
Clp0 op0 0 80f
Cln0 on0 0 80f
Bd0 dif0 0 V=v(op0)-v(on0)
Bk1_0 c1k0 0 V=v(vdd)
Bk1_0b c1k0b 0 V=v(vdd)-0.25
Bk1_1 c1k1 0 V=v(vdd)-0.25
Bk1_1b c1k1b 0 V=v(vdd)
Bk1_2 c1k2 0 V=v(vdd)-0.25
Bk1_2b c1k2b 0 V=v(vdd)
Xd1 inp inn vcm vdd 0 c1k0 c1k0b c1k1 c1k1b c1k2 c1k2b op1 on1 ctle
Clp1 op1 0 80f
Cln1 on1 0 80f
Bd1 dif1 0 V=v(op1)-v(on1)
Bk2_0 c2k0 0 V=v(vdd)-0.25
Bk2_0b c2k0b 0 V=v(vdd)
Bk2_1 c2k1 0 V=v(vdd)
Bk2_1b c2k1b 0 V=v(vdd)-0.25
Bk2_2 c2k2 0 V=v(vdd)-0.25
Bk2_2b c2k2b 0 V=v(vdd)
Xd2 inp inn vcm vdd 0 c2k0 c2k0b c2k1 c2k1b c2k2 c2k2b op2 on2 ctle
Clp2 op2 0 80f
Cln2 on2 0 80f
Bd2 dif2 0 V=v(op2)-v(on2)
Bk3_0 c3k0 0 V=v(vdd)
Bk3_0b c3k0b 0 V=v(vdd)-0.25
Bk3_1 c3k1 0 V=v(vdd)
Bk3_1b c3k1b 0 V=v(vdd)-0.25
Bk3_2 c3k2 0 V=v(vdd)-0.25
Bk3_2b c3k2b 0 V=v(vdd)
Xd3 inp inn vcm vdd 0 c3k0 c3k0b c3k1 c3k1b c3k2 c3k2b op3 on3 ctle
Clp3 op3 0 80f
Cln3 on3 0 80f
Bd3 dif3 0 V=v(op3)-v(on3)
Bk4_0 c4k0 0 V=v(vdd)-0.25
Bk4_0b c4k0b 0 V=v(vdd)
Bk4_1 c4k1 0 V=v(vdd)-0.25
Bk4_1b c4k1b 0 V=v(vdd)
Bk4_2 c4k2 0 V=v(vdd)
Bk4_2b c4k2b 0 V=v(vdd)-0.25
Xd4 inp inn vcm vdd 0 c4k0 c4k0b c4k1 c4k1b c4k2 c4k2b op4 on4 ctle
Clp4 op4 0 80f
Cln4 on4 0 80f
Bd4 dif4 0 V=v(op4)-v(on4)
Bk5_0 c5k0 0 V=v(vdd)
Bk5_0b c5k0b 0 V=v(vdd)-0.25
Bk5_1 c5k1 0 V=v(vdd)-0.25
Bk5_1b c5k1b 0 V=v(vdd)
Bk5_2 c5k2 0 V=v(vdd)
Bk5_2b c5k2b 0 V=v(vdd)-0.25
Xd5 inp inn vcm vdd 0 c5k0 c5k0b c5k1 c5k1b c5k2 c5k2b op5 on5 ctle
Clp5 op5 0 80f
Cln5 on5 0 80f
Bd5 dif5 0 V=v(op5)-v(on5)
Bk6_0 c6k0 0 V=v(vdd)-0.25
Bk6_0b c6k0b 0 V=v(vdd)
Bk6_1 c6k1 0 V=v(vdd)
Bk6_1b c6k1b 0 V=v(vdd)-0.25
Bk6_2 c6k2 0 V=v(vdd)
Bk6_2b c6k2b 0 V=v(vdd)-0.25
Xd6 inp inn vcm vdd 0 c6k0 c6k0b c6k1 c6k1b c6k2 c6k2b op6 on6 ctle
Clp6 op6 0 80f
Cln6 on6 0 80f
Bd6 dif6 0 V=v(op6)-v(on6)
Bk7_0 c7k0 0 V=v(vdd)
Bk7_0b c7k0b 0 V=v(vdd)-0.25
Bk7_1 c7k1 0 V=v(vdd)
Bk7_1b c7k1b 0 V=v(vdd)-0.25
Bk7_2 c7k2 0 V=v(vdd)
Bk7_2b c7k2b 0 V=v(vdd)-0.25
Xd7 inp inn vcm vdd 0 c7k0 c7k0b c7k1 c7k1b c7k2 c7k2b op7 on7 ctle
Clp7 op7 0 80f
Cln7 on7 0 80f
Bd7 dif7 0 V=v(op7)-v(on7)
Vdmy dmy 0 0
Rdmy dmy 0 1k
Bctle_c0_xd0_q1_vbe_node ctle_c0_xd0_q1_vbe_node 0 V=v(xd0.e1)-v(inp)
Bctle_c0_xd0_q1_vce_node ctle_c0_xd0_q1_vce_node 0 V=v(on0)-v(xd0.e1)
Bctle_c0_xd0_q2_vbe_node ctle_c0_xd0_q2_vbe_node 0 V=v(xd0.e2)-v(inn)
Bctle_c0_xd0_q2_vce_node ctle_c0_xd0_q2_vce_node 0 V=v(op0)-v(xd0.e2)
Bctle_c0_xd0_qfa_vbe_node ctle_c0_xd0_qfa_vbe_node 0 V=v(xd0.efa)-v(xd0.hpp)
Bctle_c0_xd0_qfa_vce_node ctle_c0_xd0_qfa_vce_node 0 V=v(on0)-v(xd0.efa)
Bctle_c0_xd0_qfb_vbe_node ctle_c0_xd0_qfb_vbe_node 0 V=v(xd0.efb)-v(xd0.hpn)
Bctle_c0_xd0_qfb_vce_node ctle_c0_xd0_qfb_vce_node 0 V=v(op0)-v(xd0.efb)
Bctle_c0_xd0_qa0_vbe_node ctle_c0_xd0_qa0_vbe_node 0 V=v(xd0.ea0)-v(xd0.hpp)
Bctle_c0_xd0_qa0_vce_node ctle_c0_xd0_qa0_vce_node 0 V=v(xd0.ca0)-v(xd0.ea0)
Bctle_c0_xd0_qb0_vbe_node ctle_c0_xd0_qb0_vbe_node 0 V=v(xd0.eb0)-v(xd0.hpn)
Bctle_c0_xd0_qb0_vce_node ctle_c0_xd0_qb0_vce_node 0 V=v(xd0.cb0)-v(xd0.eb0)
Bctle_c0_xd0_spa0_vbe_node ctle_c0_xd0_spa0_vbe_node 0 V=v(xd0.ca0)-v(c0k0)
Bctle_c0_xd0_spa0_vce_node ctle_c0_xd0_spa0_vce_node 0 V=v(on0)-v(xd0.ca0)
Bctle_c0_xd0_sna0_vbe_node ctle_c0_xd0_sna0_vbe_node 0 V=v(xd0.ca0)-v(c0k0b)
Bctle_c0_xd0_sna0_vce_node ctle_c0_xd0_sna0_vce_node 0 V=v(op0)-v(xd0.ca0)
Bctle_c0_xd0_spb0_vbe_node ctle_c0_xd0_spb0_vbe_node 0 V=v(xd0.cb0)-v(c0k0)
Bctle_c0_xd0_spb0_vce_node ctle_c0_xd0_spb0_vce_node 0 V=v(op0)-v(xd0.cb0)
Bctle_c0_xd0_snb0_vbe_node ctle_c0_xd0_snb0_vbe_node 0 V=v(xd0.cb0)-v(c0k0b)
Bctle_c0_xd0_snb0_vce_node ctle_c0_xd0_snb0_vce_node 0 V=v(on0)-v(xd0.cb0)
Bctle_c0_xd0_qa1_vbe_node ctle_c0_xd0_qa1_vbe_node 0 V=v(xd0.ea1)-v(xd0.hpp)
Bctle_c0_xd0_qa1_vce_node ctle_c0_xd0_qa1_vce_node 0 V=v(xd0.ca1)-v(xd0.ea1)
Bctle_c0_xd0_qb1_vbe_node ctle_c0_xd0_qb1_vbe_node 0 V=v(xd0.eb1)-v(xd0.hpn)
Bctle_c0_xd0_qb1_vce_node ctle_c0_xd0_qb1_vce_node 0 V=v(xd0.cb1)-v(xd0.eb1)
Bctle_c0_xd0_spa1_vbe_node ctle_c0_xd0_spa1_vbe_node 0 V=v(xd0.ca1)-v(c0k1)
Bctle_c0_xd0_spa1_vce_node ctle_c0_xd0_spa1_vce_node 0 V=v(on0)-v(xd0.ca1)
Bctle_c0_xd0_sna1_vbe_node ctle_c0_xd0_sna1_vbe_node 0 V=v(xd0.ca1)-v(c0k1b)
Bctle_c0_xd0_sna1_vce_node ctle_c0_xd0_sna1_vce_node 0 V=v(op0)-v(xd0.ca1)
Bctle_c0_xd0_spb1_vbe_node ctle_c0_xd0_spb1_vbe_node 0 V=v(xd0.cb1)-v(c0k1)
Bctle_c0_xd0_spb1_vce_node ctle_c0_xd0_spb1_vce_node 0 V=v(op0)-v(xd0.cb1)
Bctle_c0_xd0_snb1_vbe_node ctle_c0_xd0_snb1_vbe_node 0 V=v(xd0.cb1)-v(c0k1b)
Bctle_c0_xd0_snb1_vce_node ctle_c0_xd0_snb1_vce_node 0 V=v(on0)-v(xd0.cb1)
Bctle_c0_xd0_qa2_vbe_node ctle_c0_xd0_qa2_vbe_node 0 V=v(xd0.ea2)-v(xd0.hpp)
Bctle_c0_xd0_qa2_vce_node ctle_c0_xd0_qa2_vce_node 0 V=v(xd0.ca2)-v(xd0.ea2)
Bctle_c0_xd0_qb2_vbe_node ctle_c0_xd0_qb2_vbe_node 0 V=v(xd0.eb2)-v(xd0.hpn)
Bctle_c0_xd0_qb2_vce_node ctle_c0_xd0_qb2_vce_node 0 V=v(xd0.cb2)-v(xd0.eb2)
Bctle_c0_xd0_spa2_vbe_node ctle_c0_xd0_spa2_vbe_node 0 V=v(xd0.ca2)-v(c0k2)
Bctle_c0_xd0_spa2_vce_node ctle_c0_xd0_spa2_vce_node 0 V=v(on0)-v(xd0.ca2)
Bctle_c0_xd0_sna2_vbe_node ctle_c0_xd0_sna2_vbe_node 0 V=v(xd0.ca2)-v(c0k2b)
Bctle_c0_xd0_sna2_vce_node ctle_c0_xd0_sna2_vce_node 0 V=v(op0)-v(xd0.ca2)
Bctle_c0_xd0_spb2_vbe_node ctle_c0_xd0_spb2_vbe_node 0 V=v(xd0.cb2)-v(c0k2)
Bctle_c0_xd0_spb2_vce_node ctle_c0_xd0_spb2_vce_node 0 V=v(op0)-v(xd0.cb2)
Bctle_c0_xd0_snb2_vbe_node ctle_c0_xd0_snb2_vbe_node 0 V=v(xd0.cb2)-v(c0k2b)
Bctle_c0_xd0_snb2_vce_node ctle_c0_xd0_snb2_vce_node 0 V=v(on0)-v(xd0.cb2)
Bocm0 ocm0 0 V=(v(op0)+v(on0))/2
Bctle_c1_xd1_q1_vbe_node ctle_c1_xd1_q1_vbe_node 0 V=v(xd1.e1)-v(inp)
Bctle_c1_xd1_q1_vce_node ctle_c1_xd1_q1_vce_node 0 V=v(on1)-v(xd1.e1)
Bctle_c1_xd1_q2_vbe_node ctle_c1_xd1_q2_vbe_node 0 V=v(xd1.e2)-v(inn)
Bctle_c1_xd1_q2_vce_node ctle_c1_xd1_q2_vce_node 0 V=v(op1)-v(xd1.e2)
Bctle_c1_xd1_qfa_vbe_node ctle_c1_xd1_qfa_vbe_node 0 V=v(xd1.efa)-v(xd1.hpp)
Bctle_c1_xd1_qfa_vce_node ctle_c1_xd1_qfa_vce_node 0 V=v(on1)-v(xd1.efa)
Bctle_c1_xd1_qfb_vbe_node ctle_c1_xd1_qfb_vbe_node 0 V=v(xd1.efb)-v(xd1.hpn)
Bctle_c1_xd1_qfb_vce_node ctle_c1_xd1_qfb_vce_node 0 V=v(op1)-v(xd1.efb)
Bctle_c1_xd1_qa0_vbe_node ctle_c1_xd1_qa0_vbe_node 0 V=v(xd1.ea0)-v(xd1.hpp)
Bctle_c1_xd1_qa0_vce_node ctle_c1_xd1_qa0_vce_node 0 V=v(xd1.ca0)-v(xd1.ea0)
Bctle_c1_xd1_qb0_vbe_node ctle_c1_xd1_qb0_vbe_node 0 V=v(xd1.eb0)-v(xd1.hpn)
Bctle_c1_xd1_qb0_vce_node ctle_c1_xd1_qb0_vce_node 0 V=v(xd1.cb0)-v(xd1.eb0)
Bctle_c1_xd1_spa0_vbe_node ctle_c1_xd1_spa0_vbe_node 0 V=v(xd1.ca0)-v(c1k0)
Bctle_c1_xd1_spa0_vce_node ctle_c1_xd1_spa0_vce_node 0 V=v(on1)-v(xd1.ca0)
Bctle_c1_xd1_sna0_vbe_node ctle_c1_xd1_sna0_vbe_node 0 V=v(xd1.ca0)-v(c1k0b)
Bctle_c1_xd1_sna0_vce_node ctle_c1_xd1_sna0_vce_node 0 V=v(op1)-v(xd1.ca0)
Bctle_c1_xd1_spb0_vbe_node ctle_c1_xd1_spb0_vbe_node 0 V=v(xd1.cb0)-v(c1k0)
Bctle_c1_xd1_spb0_vce_node ctle_c1_xd1_spb0_vce_node 0 V=v(op1)-v(xd1.cb0)
Bctle_c1_xd1_snb0_vbe_node ctle_c1_xd1_snb0_vbe_node 0 V=v(xd1.cb0)-v(c1k0b)
Bctle_c1_xd1_snb0_vce_node ctle_c1_xd1_snb0_vce_node 0 V=v(on1)-v(xd1.cb0)
Bctle_c1_xd1_qa1_vbe_node ctle_c1_xd1_qa1_vbe_node 0 V=v(xd1.ea1)-v(xd1.hpp)
Bctle_c1_xd1_qa1_vce_node ctle_c1_xd1_qa1_vce_node 0 V=v(xd1.ca1)-v(xd1.ea1)
Bctle_c1_xd1_qb1_vbe_node ctle_c1_xd1_qb1_vbe_node 0 V=v(xd1.eb1)-v(xd1.hpn)
Bctle_c1_xd1_qb1_vce_node ctle_c1_xd1_qb1_vce_node 0 V=v(xd1.cb1)-v(xd1.eb1)
Bctle_c1_xd1_spa1_vbe_node ctle_c1_xd1_spa1_vbe_node 0 V=v(xd1.ca1)-v(c1k1)
Bctle_c1_xd1_spa1_vce_node ctle_c1_xd1_spa1_vce_node 0 V=v(on1)-v(xd1.ca1)
Bctle_c1_xd1_sna1_vbe_node ctle_c1_xd1_sna1_vbe_node 0 V=v(xd1.ca1)-v(c1k1b)
Bctle_c1_xd1_sna1_vce_node ctle_c1_xd1_sna1_vce_node 0 V=v(op1)-v(xd1.ca1)
Bctle_c1_xd1_spb1_vbe_node ctle_c1_xd1_spb1_vbe_node 0 V=v(xd1.cb1)-v(c1k1)
Bctle_c1_xd1_spb1_vce_node ctle_c1_xd1_spb1_vce_node 0 V=v(op1)-v(xd1.cb1)
Bctle_c1_xd1_snb1_vbe_node ctle_c1_xd1_snb1_vbe_node 0 V=v(xd1.cb1)-v(c1k1b)
Bctle_c1_xd1_snb1_vce_node ctle_c1_xd1_snb1_vce_node 0 V=v(on1)-v(xd1.cb1)
Bctle_c1_xd1_qa2_vbe_node ctle_c1_xd1_qa2_vbe_node 0 V=v(xd1.ea2)-v(xd1.hpp)
Bctle_c1_xd1_qa2_vce_node ctle_c1_xd1_qa2_vce_node 0 V=v(xd1.ca2)-v(xd1.ea2)
Bctle_c1_xd1_qb2_vbe_node ctle_c1_xd1_qb2_vbe_node 0 V=v(xd1.eb2)-v(xd1.hpn)
Bctle_c1_xd1_qb2_vce_node ctle_c1_xd1_qb2_vce_node 0 V=v(xd1.cb2)-v(xd1.eb2)
Bctle_c1_xd1_spa2_vbe_node ctle_c1_xd1_spa2_vbe_node 0 V=v(xd1.ca2)-v(c1k2)
Bctle_c1_xd1_spa2_vce_node ctle_c1_xd1_spa2_vce_node 0 V=v(on1)-v(xd1.ca2)
Bctle_c1_xd1_sna2_vbe_node ctle_c1_xd1_sna2_vbe_node 0 V=v(xd1.ca2)-v(c1k2b)
Bctle_c1_xd1_sna2_vce_node ctle_c1_xd1_sna2_vce_node 0 V=v(op1)-v(xd1.ca2)
Bctle_c1_xd1_spb2_vbe_node ctle_c1_xd1_spb2_vbe_node 0 V=v(xd1.cb2)-v(c1k2)
Bctle_c1_xd1_spb2_vce_node ctle_c1_xd1_spb2_vce_node 0 V=v(op1)-v(xd1.cb2)
Bctle_c1_xd1_snb2_vbe_node ctle_c1_xd1_snb2_vbe_node 0 V=v(xd1.cb2)-v(c1k2b)
Bctle_c1_xd1_snb2_vce_node ctle_c1_xd1_snb2_vce_node 0 V=v(on1)-v(xd1.cb2)
Bocm1 ocm1 0 V=(v(op1)+v(on1))/2
Bctle_c2_xd2_q1_vbe_node ctle_c2_xd2_q1_vbe_node 0 V=v(xd2.e1)-v(inp)
Bctle_c2_xd2_q1_vce_node ctle_c2_xd2_q1_vce_node 0 V=v(on2)-v(xd2.e1)
Bctle_c2_xd2_q2_vbe_node ctle_c2_xd2_q2_vbe_node 0 V=v(xd2.e2)-v(inn)
Bctle_c2_xd2_q2_vce_node ctle_c2_xd2_q2_vce_node 0 V=v(op2)-v(xd2.e2)
Bctle_c2_xd2_qfa_vbe_node ctle_c2_xd2_qfa_vbe_node 0 V=v(xd2.efa)-v(xd2.hpp)
Bctle_c2_xd2_qfa_vce_node ctle_c2_xd2_qfa_vce_node 0 V=v(on2)-v(xd2.efa)
Bctle_c2_xd2_qfb_vbe_node ctle_c2_xd2_qfb_vbe_node 0 V=v(xd2.efb)-v(xd2.hpn)
Bctle_c2_xd2_qfb_vce_node ctle_c2_xd2_qfb_vce_node 0 V=v(op2)-v(xd2.efb)
Bctle_c2_xd2_qa0_vbe_node ctle_c2_xd2_qa0_vbe_node 0 V=v(xd2.ea0)-v(xd2.hpp)
Bctle_c2_xd2_qa0_vce_node ctle_c2_xd2_qa0_vce_node 0 V=v(xd2.ca0)-v(xd2.ea0)
Bctle_c2_xd2_qb0_vbe_node ctle_c2_xd2_qb0_vbe_node 0 V=v(xd2.eb0)-v(xd2.hpn)
Bctle_c2_xd2_qb0_vce_node ctle_c2_xd2_qb0_vce_node 0 V=v(xd2.cb0)-v(xd2.eb0)
Bctle_c2_xd2_spa0_vbe_node ctle_c2_xd2_spa0_vbe_node 0 V=v(xd2.ca0)-v(c2k0)
Bctle_c2_xd2_spa0_vce_node ctle_c2_xd2_spa0_vce_node 0 V=v(on2)-v(xd2.ca0)
Bctle_c2_xd2_sna0_vbe_node ctle_c2_xd2_sna0_vbe_node 0 V=v(xd2.ca0)-v(c2k0b)
Bctle_c2_xd2_sna0_vce_node ctle_c2_xd2_sna0_vce_node 0 V=v(op2)-v(xd2.ca0)
Bctle_c2_xd2_spb0_vbe_node ctle_c2_xd2_spb0_vbe_node 0 V=v(xd2.cb0)-v(c2k0)
Bctle_c2_xd2_spb0_vce_node ctle_c2_xd2_spb0_vce_node 0 V=v(op2)-v(xd2.cb0)
Bctle_c2_xd2_snb0_vbe_node ctle_c2_xd2_snb0_vbe_node 0 V=v(xd2.cb0)-v(c2k0b)
Bctle_c2_xd2_snb0_vce_node ctle_c2_xd2_snb0_vce_node 0 V=v(on2)-v(xd2.cb0)
Bctle_c2_xd2_qa1_vbe_node ctle_c2_xd2_qa1_vbe_node 0 V=v(xd2.ea1)-v(xd2.hpp)
Bctle_c2_xd2_qa1_vce_node ctle_c2_xd2_qa1_vce_node 0 V=v(xd2.ca1)-v(xd2.ea1)
Bctle_c2_xd2_qb1_vbe_node ctle_c2_xd2_qb1_vbe_node 0 V=v(xd2.eb1)-v(xd2.hpn)
Bctle_c2_xd2_qb1_vce_node ctle_c2_xd2_qb1_vce_node 0 V=v(xd2.cb1)-v(xd2.eb1)
Bctle_c2_xd2_spa1_vbe_node ctle_c2_xd2_spa1_vbe_node 0 V=v(xd2.ca1)-v(c2k1)
Bctle_c2_xd2_spa1_vce_node ctle_c2_xd2_spa1_vce_node 0 V=v(on2)-v(xd2.ca1)
Bctle_c2_xd2_sna1_vbe_node ctle_c2_xd2_sna1_vbe_node 0 V=v(xd2.ca1)-v(c2k1b)
Bctle_c2_xd2_sna1_vce_node ctle_c2_xd2_sna1_vce_node 0 V=v(op2)-v(xd2.ca1)
Bctle_c2_xd2_spb1_vbe_node ctle_c2_xd2_spb1_vbe_node 0 V=v(xd2.cb1)-v(c2k1)
Bctle_c2_xd2_spb1_vce_node ctle_c2_xd2_spb1_vce_node 0 V=v(op2)-v(xd2.cb1)
Bctle_c2_xd2_snb1_vbe_node ctle_c2_xd2_snb1_vbe_node 0 V=v(xd2.cb1)-v(c2k1b)
Bctle_c2_xd2_snb1_vce_node ctle_c2_xd2_snb1_vce_node 0 V=v(on2)-v(xd2.cb1)
Bctle_c2_xd2_qa2_vbe_node ctle_c2_xd2_qa2_vbe_node 0 V=v(xd2.ea2)-v(xd2.hpp)
Bctle_c2_xd2_qa2_vce_node ctle_c2_xd2_qa2_vce_node 0 V=v(xd2.ca2)-v(xd2.ea2)
Bctle_c2_xd2_qb2_vbe_node ctle_c2_xd2_qb2_vbe_node 0 V=v(xd2.eb2)-v(xd2.hpn)
Bctle_c2_xd2_qb2_vce_node ctle_c2_xd2_qb2_vce_node 0 V=v(xd2.cb2)-v(xd2.eb2)
Bctle_c2_xd2_spa2_vbe_node ctle_c2_xd2_spa2_vbe_node 0 V=v(xd2.ca2)-v(c2k2)
Bctle_c2_xd2_spa2_vce_node ctle_c2_xd2_spa2_vce_node 0 V=v(on2)-v(xd2.ca2)
Bctle_c2_xd2_sna2_vbe_node ctle_c2_xd2_sna2_vbe_node 0 V=v(xd2.ca2)-v(c2k2b)
Bctle_c2_xd2_sna2_vce_node ctle_c2_xd2_sna2_vce_node 0 V=v(op2)-v(xd2.ca2)
Bctle_c2_xd2_spb2_vbe_node ctle_c2_xd2_spb2_vbe_node 0 V=v(xd2.cb2)-v(c2k2)
Bctle_c2_xd2_spb2_vce_node ctle_c2_xd2_spb2_vce_node 0 V=v(op2)-v(xd2.cb2)
Bctle_c2_xd2_snb2_vbe_node ctle_c2_xd2_snb2_vbe_node 0 V=v(xd2.cb2)-v(c2k2b)
Bctle_c2_xd2_snb2_vce_node ctle_c2_xd2_snb2_vce_node 0 V=v(on2)-v(xd2.cb2)
Bocm2 ocm2 0 V=(v(op2)+v(on2))/2
Bctle_c3_xd3_q1_vbe_node ctle_c3_xd3_q1_vbe_node 0 V=v(xd3.e1)-v(inp)
Bctle_c3_xd3_q1_vce_node ctle_c3_xd3_q1_vce_node 0 V=v(on3)-v(xd3.e1)
Bctle_c3_xd3_q2_vbe_node ctle_c3_xd3_q2_vbe_node 0 V=v(xd3.e2)-v(inn)
Bctle_c3_xd3_q2_vce_node ctle_c3_xd3_q2_vce_node 0 V=v(op3)-v(xd3.e2)
Bctle_c3_xd3_qfa_vbe_node ctle_c3_xd3_qfa_vbe_node 0 V=v(xd3.efa)-v(xd3.hpp)
Bctle_c3_xd3_qfa_vce_node ctle_c3_xd3_qfa_vce_node 0 V=v(on3)-v(xd3.efa)
Bctle_c3_xd3_qfb_vbe_node ctle_c3_xd3_qfb_vbe_node 0 V=v(xd3.efb)-v(xd3.hpn)
Bctle_c3_xd3_qfb_vce_node ctle_c3_xd3_qfb_vce_node 0 V=v(op3)-v(xd3.efb)
Bctle_c3_xd3_qa0_vbe_node ctle_c3_xd3_qa0_vbe_node 0 V=v(xd3.ea0)-v(xd3.hpp)
Bctle_c3_xd3_qa0_vce_node ctle_c3_xd3_qa0_vce_node 0 V=v(xd3.ca0)-v(xd3.ea0)
Bctle_c3_xd3_qb0_vbe_node ctle_c3_xd3_qb0_vbe_node 0 V=v(xd3.eb0)-v(xd3.hpn)
Bctle_c3_xd3_qb0_vce_node ctle_c3_xd3_qb0_vce_node 0 V=v(xd3.cb0)-v(xd3.eb0)
Bctle_c3_xd3_spa0_vbe_node ctle_c3_xd3_spa0_vbe_node 0 V=v(xd3.ca0)-v(c3k0)
Bctle_c3_xd3_spa0_vce_node ctle_c3_xd3_spa0_vce_node 0 V=v(on3)-v(xd3.ca0)
Bctle_c3_xd3_sna0_vbe_node ctle_c3_xd3_sna0_vbe_node 0 V=v(xd3.ca0)-v(c3k0b)
Bctle_c3_xd3_sna0_vce_node ctle_c3_xd3_sna0_vce_node 0 V=v(op3)-v(xd3.ca0)
Bctle_c3_xd3_spb0_vbe_node ctle_c3_xd3_spb0_vbe_node 0 V=v(xd3.cb0)-v(c3k0)
Bctle_c3_xd3_spb0_vce_node ctle_c3_xd3_spb0_vce_node 0 V=v(op3)-v(xd3.cb0)
Bctle_c3_xd3_snb0_vbe_node ctle_c3_xd3_snb0_vbe_node 0 V=v(xd3.cb0)-v(c3k0b)
Bctle_c3_xd3_snb0_vce_node ctle_c3_xd3_snb0_vce_node 0 V=v(on3)-v(xd3.cb0)
Bctle_c3_xd3_qa1_vbe_node ctle_c3_xd3_qa1_vbe_node 0 V=v(xd3.ea1)-v(xd3.hpp)
Bctle_c3_xd3_qa1_vce_node ctle_c3_xd3_qa1_vce_node 0 V=v(xd3.ca1)-v(xd3.ea1)
Bctle_c3_xd3_qb1_vbe_node ctle_c3_xd3_qb1_vbe_node 0 V=v(xd3.eb1)-v(xd3.hpn)
Bctle_c3_xd3_qb1_vce_node ctle_c3_xd3_qb1_vce_node 0 V=v(xd3.cb1)-v(xd3.eb1)
Bctle_c3_xd3_spa1_vbe_node ctle_c3_xd3_spa1_vbe_node 0 V=v(xd3.ca1)-v(c3k1)
Bctle_c3_xd3_spa1_vce_node ctle_c3_xd3_spa1_vce_node 0 V=v(on3)-v(xd3.ca1)
Bctle_c3_xd3_sna1_vbe_node ctle_c3_xd3_sna1_vbe_node 0 V=v(xd3.ca1)-v(c3k1b)
Bctle_c3_xd3_sna1_vce_node ctle_c3_xd3_sna1_vce_node 0 V=v(op3)-v(xd3.ca1)
Bctle_c3_xd3_spb1_vbe_node ctle_c3_xd3_spb1_vbe_node 0 V=v(xd3.cb1)-v(c3k1)
Bctle_c3_xd3_spb1_vce_node ctle_c3_xd3_spb1_vce_node 0 V=v(op3)-v(xd3.cb1)
Bctle_c3_xd3_snb1_vbe_node ctle_c3_xd3_snb1_vbe_node 0 V=v(xd3.cb1)-v(c3k1b)
Bctle_c3_xd3_snb1_vce_node ctle_c3_xd3_snb1_vce_node 0 V=v(on3)-v(xd3.cb1)
Bctle_c3_xd3_qa2_vbe_node ctle_c3_xd3_qa2_vbe_node 0 V=v(xd3.ea2)-v(xd3.hpp)
Bctle_c3_xd3_qa2_vce_node ctle_c3_xd3_qa2_vce_node 0 V=v(xd3.ca2)-v(xd3.ea2)
Bctle_c3_xd3_qb2_vbe_node ctle_c3_xd3_qb2_vbe_node 0 V=v(xd3.eb2)-v(xd3.hpn)
Bctle_c3_xd3_qb2_vce_node ctle_c3_xd3_qb2_vce_node 0 V=v(xd3.cb2)-v(xd3.eb2)
Bctle_c3_xd3_spa2_vbe_node ctle_c3_xd3_spa2_vbe_node 0 V=v(xd3.ca2)-v(c3k2)
Bctle_c3_xd3_spa2_vce_node ctle_c3_xd3_spa2_vce_node 0 V=v(on3)-v(xd3.ca2)
Bctle_c3_xd3_sna2_vbe_node ctle_c3_xd3_sna2_vbe_node 0 V=v(xd3.ca2)-v(c3k2b)
Bctle_c3_xd3_sna2_vce_node ctle_c3_xd3_sna2_vce_node 0 V=v(op3)-v(xd3.ca2)
Bctle_c3_xd3_spb2_vbe_node ctle_c3_xd3_spb2_vbe_node 0 V=v(xd3.cb2)-v(c3k2)
Bctle_c3_xd3_spb2_vce_node ctle_c3_xd3_spb2_vce_node 0 V=v(op3)-v(xd3.cb2)
Bctle_c3_xd3_snb2_vbe_node ctle_c3_xd3_snb2_vbe_node 0 V=v(xd3.cb2)-v(c3k2b)
Bctle_c3_xd3_snb2_vce_node ctle_c3_xd3_snb2_vce_node 0 V=v(on3)-v(xd3.cb2)
Bocm3 ocm3 0 V=(v(op3)+v(on3))/2
Bctle_c4_xd4_q1_vbe_node ctle_c4_xd4_q1_vbe_node 0 V=v(xd4.e1)-v(inp)
Bctle_c4_xd4_q1_vce_node ctle_c4_xd4_q1_vce_node 0 V=v(on4)-v(xd4.e1)
Bctle_c4_xd4_q2_vbe_node ctle_c4_xd4_q2_vbe_node 0 V=v(xd4.e2)-v(inn)
Bctle_c4_xd4_q2_vce_node ctle_c4_xd4_q2_vce_node 0 V=v(op4)-v(xd4.e2)
Bctle_c4_xd4_qfa_vbe_node ctle_c4_xd4_qfa_vbe_node 0 V=v(xd4.efa)-v(xd4.hpp)
Bctle_c4_xd4_qfa_vce_node ctle_c4_xd4_qfa_vce_node 0 V=v(on4)-v(xd4.efa)
Bctle_c4_xd4_qfb_vbe_node ctle_c4_xd4_qfb_vbe_node 0 V=v(xd4.efb)-v(xd4.hpn)
Bctle_c4_xd4_qfb_vce_node ctle_c4_xd4_qfb_vce_node 0 V=v(op4)-v(xd4.efb)
Bctle_c4_xd4_qa0_vbe_node ctle_c4_xd4_qa0_vbe_node 0 V=v(xd4.ea0)-v(xd4.hpp)
Bctle_c4_xd4_qa0_vce_node ctle_c4_xd4_qa0_vce_node 0 V=v(xd4.ca0)-v(xd4.ea0)
Bctle_c4_xd4_qb0_vbe_node ctle_c4_xd4_qb0_vbe_node 0 V=v(xd4.eb0)-v(xd4.hpn)
Bctle_c4_xd4_qb0_vce_node ctle_c4_xd4_qb0_vce_node 0 V=v(xd4.cb0)-v(xd4.eb0)
Bctle_c4_xd4_spa0_vbe_node ctle_c4_xd4_spa0_vbe_node 0 V=v(xd4.ca0)-v(c4k0)
Bctle_c4_xd4_spa0_vce_node ctle_c4_xd4_spa0_vce_node 0 V=v(on4)-v(xd4.ca0)
Bctle_c4_xd4_sna0_vbe_node ctle_c4_xd4_sna0_vbe_node 0 V=v(xd4.ca0)-v(c4k0b)
Bctle_c4_xd4_sna0_vce_node ctle_c4_xd4_sna0_vce_node 0 V=v(op4)-v(xd4.ca0)
Bctle_c4_xd4_spb0_vbe_node ctle_c4_xd4_spb0_vbe_node 0 V=v(xd4.cb0)-v(c4k0)
Bctle_c4_xd4_spb0_vce_node ctle_c4_xd4_spb0_vce_node 0 V=v(op4)-v(xd4.cb0)
Bctle_c4_xd4_snb0_vbe_node ctle_c4_xd4_snb0_vbe_node 0 V=v(xd4.cb0)-v(c4k0b)
Bctle_c4_xd4_snb0_vce_node ctle_c4_xd4_snb0_vce_node 0 V=v(on4)-v(xd4.cb0)
Bctle_c4_xd4_qa1_vbe_node ctle_c4_xd4_qa1_vbe_node 0 V=v(xd4.ea1)-v(xd4.hpp)
Bctle_c4_xd4_qa1_vce_node ctle_c4_xd4_qa1_vce_node 0 V=v(xd4.ca1)-v(xd4.ea1)
Bctle_c4_xd4_qb1_vbe_node ctle_c4_xd4_qb1_vbe_node 0 V=v(xd4.eb1)-v(xd4.hpn)
Bctle_c4_xd4_qb1_vce_node ctle_c4_xd4_qb1_vce_node 0 V=v(xd4.cb1)-v(xd4.eb1)
Bctle_c4_xd4_spa1_vbe_node ctle_c4_xd4_spa1_vbe_node 0 V=v(xd4.ca1)-v(c4k1)
Bctle_c4_xd4_spa1_vce_node ctle_c4_xd4_spa1_vce_node 0 V=v(on4)-v(xd4.ca1)
Bctle_c4_xd4_sna1_vbe_node ctle_c4_xd4_sna1_vbe_node 0 V=v(xd4.ca1)-v(c4k1b)
Bctle_c4_xd4_sna1_vce_node ctle_c4_xd4_sna1_vce_node 0 V=v(op4)-v(xd4.ca1)
Bctle_c4_xd4_spb1_vbe_node ctle_c4_xd4_spb1_vbe_node 0 V=v(xd4.cb1)-v(c4k1)
Bctle_c4_xd4_spb1_vce_node ctle_c4_xd4_spb1_vce_node 0 V=v(op4)-v(xd4.cb1)
Bctle_c4_xd4_snb1_vbe_node ctle_c4_xd4_snb1_vbe_node 0 V=v(xd4.cb1)-v(c4k1b)
Bctle_c4_xd4_snb1_vce_node ctle_c4_xd4_snb1_vce_node 0 V=v(on4)-v(xd4.cb1)
Bctle_c4_xd4_qa2_vbe_node ctle_c4_xd4_qa2_vbe_node 0 V=v(xd4.ea2)-v(xd4.hpp)
Bctle_c4_xd4_qa2_vce_node ctle_c4_xd4_qa2_vce_node 0 V=v(xd4.ca2)-v(xd4.ea2)
Bctle_c4_xd4_qb2_vbe_node ctle_c4_xd4_qb2_vbe_node 0 V=v(xd4.eb2)-v(xd4.hpn)
Bctle_c4_xd4_qb2_vce_node ctle_c4_xd4_qb2_vce_node 0 V=v(xd4.cb2)-v(xd4.eb2)
Bctle_c4_xd4_spa2_vbe_node ctle_c4_xd4_spa2_vbe_node 0 V=v(xd4.ca2)-v(c4k2)
Bctle_c4_xd4_spa2_vce_node ctle_c4_xd4_spa2_vce_node 0 V=v(on4)-v(xd4.ca2)
Bctle_c4_xd4_sna2_vbe_node ctle_c4_xd4_sna2_vbe_node 0 V=v(xd4.ca2)-v(c4k2b)
Bctle_c4_xd4_sna2_vce_node ctle_c4_xd4_sna2_vce_node 0 V=v(op4)-v(xd4.ca2)
Bctle_c4_xd4_spb2_vbe_node ctle_c4_xd4_spb2_vbe_node 0 V=v(xd4.cb2)-v(c4k2)
Bctle_c4_xd4_spb2_vce_node ctle_c4_xd4_spb2_vce_node 0 V=v(op4)-v(xd4.cb2)
Bctle_c4_xd4_snb2_vbe_node ctle_c4_xd4_snb2_vbe_node 0 V=v(xd4.cb2)-v(c4k2b)
Bctle_c4_xd4_snb2_vce_node ctle_c4_xd4_snb2_vce_node 0 V=v(on4)-v(xd4.cb2)
Bocm4 ocm4 0 V=(v(op4)+v(on4))/2
Bctle_c5_xd5_q1_vbe_node ctle_c5_xd5_q1_vbe_node 0 V=v(xd5.e1)-v(inp)
Bctle_c5_xd5_q1_vce_node ctle_c5_xd5_q1_vce_node 0 V=v(on5)-v(xd5.e1)
Bctle_c5_xd5_q2_vbe_node ctle_c5_xd5_q2_vbe_node 0 V=v(xd5.e2)-v(inn)
Bctle_c5_xd5_q2_vce_node ctle_c5_xd5_q2_vce_node 0 V=v(op5)-v(xd5.e2)
Bctle_c5_xd5_qfa_vbe_node ctle_c5_xd5_qfa_vbe_node 0 V=v(xd5.efa)-v(xd5.hpp)
Bctle_c5_xd5_qfa_vce_node ctle_c5_xd5_qfa_vce_node 0 V=v(on5)-v(xd5.efa)
Bctle_c5_xd5_qfb_vbe_node ctle_c5_xd5_qfb_vbe_node 0 V=v(xd5.efb)-v(xd5.hpn)
Bctle_c5_xd5_qfb_vce_node ctle_c5_xd5_qfb_vce_node 0 V=v(op5)-v(xd5.efb)
Bctle_c5_xd5_qa0_vbe_node ctle_c5_xd5_qa0_vbe_node 0 V=v(xd5.ea0)-v(xd5.hpp)
Bctle_c5_xd5_qa0_vce_node ctle_c5_xd5_qa0_vce_node 0 V=v(xd5.ca0)-v(xd5.ea0)
Bctle_c5_xd5_qb0_vbe_node ctle_c5_xd5_qb0_vbe_node 0 V=v(xd5.eb0)-v(xd5.hpn)
Bctle_c5_xd5_qb0_vce_node ctle_c5_xd5_qb0_vce_node 0 V=v(xd5.cb0)-v(xd5.eb0)
Bctle_c5_xd5_spa0_vbe_node ctle_c5_xd5_spa0_vbe_node 0 V=v(xd5.ca0)-v(c5k0)
Bctle_c5_xd5_spa0_vce_node ctle_c5_xd5_spa0_vce_node 0 V=v(on5)-v(xd5.ca0)
Bctle_c5_xd5_sna0_vbe_node ctle_c5_xd5_sna0_vbe_node 0 V=v(xd5.ca0)-v(c5k0b)
Bctle_c5_xd5_sna0_vce_node ctle_c5_xd5_sna0_vce_node 0 V=v(op5)-v(xd5.ca0)
Bctle_c5_xd5_spb0_vbe_node ctle_c5_xd5_spb0_vbe_node 0 V=v(xd5.cb0)-v(c5k0)
Bctle_c5_xd5_spb0_vce_node ctle_c5_xd5_spb0_vce_node 0 V=v(op5)-v(xd5.cb0)
Bctle_c5_xd5_snb0_vbe_node ctle_c5_xd5_snb0_vbe_node 0 V=v(xd5.cb0)-v(c5k0b)
Bctle_c5_xd5_snb0_vce_node ctle_c5_xd5_snb0_vce_node 0 V=v(on5)-v(xd5.cb0)
Bctle_c5_xd5_qa1_vbe_node ctle_c5_xd5_qa1_vbe_node 0 V=v(xd5.ea1)-v(xd5.hpp)
Bctle_c5_xd5_qa1_vce_node ctle_c5_xd5_qa1_vce_node 0 V=v(xd5.ca1)-v(xd5.ea1)
Bctle_c5_xd5_qb1_vbe_node ctle_c5_xd5_qb1_vbe_node 0 V=v(xd5.eb1)-v(xd5.hpn)
Bctle_c5_xd5_qb1_vce_node ctle_c5_xd5_qb1_vce_node 0 V=v(xd5.cb1)-v(xd5.eb1)
Bctle_c5_xd5_spa1_vbe_node ctle_c5_xd5_spa1_vbe_node 0 V=v(xd5.ca1)-v(c5k1)
Bctle_c5_xd5_spa1_vce_node ctle_c5_xd5_spa1_vce_node 0 V=v(on5)-v(xd5.ca1)
Bctle_c5_xd5_sna1_vbe_node ctle_c5_xd5_sna1_vbe_node 0 V=v(xd5.ca1)-v(c5k1b)
Bctle_c5_xd5_sna1_vce_node ctle_c5_xd5_sna1_vce_node 0 V=v(op5)-v(xd5.ca1)
Bctle_c5_xd5_spb1_vbe_node ctle_c5_xd5_spb1_vbe_node 0 V=v(xd5.cb1)-v(c5k1)
Bctle_c5_xd5_spb1_vce_node ctle_c5_xd5_spb1_vce_node 0 V=v(op5)-v(xd5.cb1)
Bctle_c5_xd5_snb1_vbe_node ctle_c5_xd5_snb1_vbe_node 0 V=v(xd5.cb1)-v(c5k1b)
Bctle_c5_xd5_snb1_vce_node ctle_c5_xd5_snb1_vce_node 0 V=v(on5)-v(xd5.cb1)
Bctle_c5_xd5_qa2_vbe_node ctle_c5_xd5_qa2_vbe_node 0 V=v(xd5.ea2)-v(xd5.hpp)
Bctle_c5_xd5_qa2_vce_node ctle_c5_xd5_qa2_vce_node 0 V=v(xd5.ca2)-v(xd5.ea2)
Bctle_c5_xd5_qb2_vbe_node ctle_c5_xd5_qb2_vbe_node 0 V=v(xd5.eb2)-v(xd5.hpn)
Bctle_c5_xd5_qb2_vce_node ctle_c5_xd5_qb2_vce_node 0 V=v(xd5.cb2)-v(xd5.eb2)
Bctle_c5_xd5_spa2_vbe_node ctle_c5_xd5_spa2_vbe_node 0 V=v(xd5.ca2)-v(c5k2)
Bctle_c5_xd5_spa2_vce_node ctle_c5_xd5_spa2_vce_node 0 V=v(on5)-v(xd5.ca2)
Bctle_c5_xd5_sna2_vbe_node ctle_c5_xd5_sna2_vbe_node 0 V=v(xd5.ca2)-v(c5k2b)
Bctle_c5_xd5_sna2_vce_node ctle_c5_xd5_sna2_vce_node 0 V=v(op5)-v(xd5.ca2)
Bctle_c5_xd5_spb2_vbe_node ctle_c5_xd5_spb2_vbe_node 0 V=v(xd5.cb2)-v(c5k2)
Bctle_c5_xd5_spb2_vce_node ctle_c5_xd5_spb2_vce_node 0 V=v(op5)-v(xd5.cb2)
Bctle_c5_xd5_snb2_vbe_node ctle_c5_xd5_snb2_vbe_node 0 V=v(xd5.cb2)-v(c5k2b)
Bctle_c5_xd5_snb2_vce_node ctle_c5_xd5_snb2_vce_node 0 V=v(on5)-v(xd5.cb2)
Bocm5 ocm5 0 V=(v(op5)+v(on5))/2
Bctle_c6_xd6_q1_vbe_node ctle_c6_xd6_q1_vbe_node 0 V=v(xd6.e1)-v(inp)
Bctle_c6_xd6_q1_vce_node ctle_c6_xd6_q1_vce_node 0 V=v(on6)-v(xd6.e1)
Bctle_c6_xd6_q2_vbe_node ctle_c6_xd6_q2_vbe_node 0 V=v(xd6.e2)-v(inn)
Bctle_c6_xd6_q2_vce_node ctle_c6_xd6_q2_vce_node 0 V=v(op6)-v(xd6.e2)
Bctle_c6_xd6_qfa_vbe_node ctle_c6_xd6_qfa_vbe_node 0 V=v(xd6.efa)-v(xd6.hpp)
Bctle_c6_xd6_qfa_vce_node ctle_c6_xd6_qfa_vce_node 0 V=v(on6)-v(xd6.efa)
Bctle_c6_xd6_qfb_vbe_node ctle_c6_xd6_qfb_vbe_node 0 V=v(xd6.efb)-v(xd6.hpn)
Bctle_c6_xd6_qfb_vce_node ctle_c6_xd6_qfb_vce_node 0 V=v(op6)-v(xd6.efb)
Bctle_c6_xd6_qa0_vbe_node ctle_c6_xd6_qa0_vbe_node 0 V=v(xd6.ea0)-v(xd6.hpp)
Bctle_c6_xd6_qa0_vce_node ctle_c6_xd6_qa0_vce_node 0 V=v(xd6.ca0)-v(xd6.ea0)
Bctle_c6_xd6_qb0_vbe_node ctle_c6_xd6_qb0_vbe_node 0 V=v(xd6.eb0)-v(xd6.hpn)
Bctle_c6_xd6_qb0_vce_node ctle_c6_xd6_qb0_vce_node 0 V=v(xd6.cb0)-v(xd6.eb0)
Bctle_c6_xd6_spa0_vbe_node ctle_c6_xd6_spa0_vbe_node 0 V=v(xd6.ca0)-v(c6k0)
Bctle_c6_xd6_spa0_vce_node ctle_c6_xd6_spa0_vce_node 0 V=v(on6)-v(xd6.ca0)
Bctle_c6_xd6_sna0_vbe_node ctle_c6_xd6_sna0_vbe_node 0 V=v(xd6.ca0)-v(c6k0b)
Bctle_c6_xd6_sna0_vce_node ctle_c6_xd6_sna0_vce_node 0 V=v(op6)-v(xd6.ca0)
Bctle_c6_xd6_spb0_vbe_node ctle_c6_xd6_spb0_vbe_node 0 V=v(xd6.cb0)-v(c6k0)
Bctle_c6_xd6_spb0_vce_node ctle_c6_xd6_spb0_vce_node 0 V=v(op6)-v(xd6.cb0)
Bctle_c6_xd6_snb0_vbe_node ctle_c6_xd6_snb0_vbe_node 0 V=v(xd6.cb0)-v(c6k0b)
Bctle_c6_xd6_snb0_vce_node ctle_c6_xd6_snb0_vce_node 0 V=v(on6)-v(xd6.cb0)
Bctle_c6_xd6_qa1_vbe_node ctle_c6_xd6_qa1_vbe_node 0 V=v(xd6.ea1)-v(xd6.hpp)
Bctle_c6_xd6_qa1_vce_node ctle_c6_xd6_qa1_vce_node 0 V=v(xd6.ca1)-v(xd6.ea1)
Bctle_c6_xd6_qb1_vbe_node ctle_c6_xd6_qb1_vbe_node 0 V=v(xd6.eb1)-v(xd6.hpn)
Bctle_c6_xd6_qb1_vce_node ctle_c6_xd6_qb1_vce_node 0 V=v(xd6.cb1)-v(xd6.eb1)
Bctle_c6_xd6_spa1_vbe_node ctle_c6_xd6_spa1_vbe_node 0 V=v(xd6.ca1)-v(c6k1)
Bctle_c6_xd6_spa1_vce_node ctle_c6_xd6_spa1_vce_node 0 V=v(on6)-v(xd6.ca1)
Bctle_c6_xd6_sna1_vbe_node ctle_c6_xd6_sna1_vbe_node 0 V=v(xd6.ca1)-v(c6k1b)
Bctle_c6_xd6_sna1_vce_node ctle_c6_xd6_sna1_vce_node 0 V=v(op6)-v(xd6.ca1)
Bctle_c6_xd6_spb1_vbe_node ctle_c6_xd6_spb1_vbe_node 0 V=v(xd6.cb1)-v(c6k1)
Bctle_c6_xd6_spb1_vce_node ctle_c6_xd6_spb1_vce_node 0 V=v(op6)-v(xd6.cb1)
Bctle_c6_xd6_snb1_vbe_node ctle_c6_xd6_snb1_vbe_node 0 V=v(xd6.cb1)-v(c6k1b)
Bctle_c6_xd6_snb1_vce_node ctle_c6_xd6_snb1_vce_node 0 V=v(on6)-v(xd6.cb1)
Bctle_c6_xd6_qa2_vbe_node ctle_c6_xd6_qa2_vbe_node 0 V=v(xd6.ea2)-v(xd6.hpp)
Bctle_c6_xd6_qa2_vce_node ctle_c6_xd6_qa2_vce_node 0 V=v(xd6.ca2)-v(xd6.ea2)
Bctle_c6_xd6_qb2_vbe_node ctle_c6_xd6_qb2_vbe_node 0 V=v(xd6.eb2)-v(xd6.hpn)
Bctle_c6_xd6_qb2_vce_node ctle_c6_xd6_qb2_vce_node 0 V=v(xd6.cb2)-v(xd6.eb2)
Bctle_c6_xd6_spa2_vbe_node ctle_c6_xd6_spa2_vbe_node 0 V=v(xd6.ca2)-v(c6k2)
Bctle_c6_xd6_spa2_vce_node ctle_c6_xd6_spa2_vce_node 0 V=v(on6)-v(xd6.ca2)
Bctle_c6_xd6_sna2_vbe_node ctle_c6_xd6_sna2_vbe_node 0 V=v(xd6.ca2)-v(c6k2b)
Bctle_c6_xd6_sna2_vce_node ctle_c6_xd6_sna2_vce_node 0 V=v(op6)-v(xd6.ca2)
Bctle_c6_xd6_spb2_vbe_node ctle_c6_xd6_spb2_vbe_node 0 V=v(xd6.cb2)-v(c6k2)
Bctle_c6_xd6_spb2_vce_node ctle_c6_xd6_spb2_vce_node 0 V=v(op6)-v(xd6.cb2)
Bctle_c6_xd6_snb2_vbe_node ctle_c6_xd6_snb2_vbe_node 0 V=v(xd6.cb2)-v(c6k2b)
Bctle_c6_xd6_snb2_vce_node ctle_c6_xd6_snb2_vce_node 0 V=v(on6)-v(xd6.cb2)
Bocm6 ocm6 0 V=(v(op6)+v(on6))/2
Bctle_c7_xd7_q1_vbe_node ctle_c7_xd7_q1_vbe_node 0 V=v(xd7.e1)-v(inp)
Bctle_c7_xd7_q1_vce_node ctle_c7_xd7_q1_vce_node 0 V=v(on7)-v(xd7.e1)
Bctle_c7_xd7_q2_vbe_node ctle_c7_xd7_q2_vbe_node 0 V=v(xd7.e2)-v(inn)
Bctle_c7_xd7_q2_vce_node ctle_c7_xd7_q2_vce_node 0 V=v(op7)-v(xd7.e2)
Bctle_c7_xd7_qfa_vbe_node ctle_c7_xd7_qfa_vbe_node 0 V=v(xd7.efa)-v(xd7.hpp)
Bctle_c7_xd7_qfa_vce_node ctle_c7_xd7_qfa_vce_node 0 V=v(on7)-v(xd7.efa)
Bctle_c7_xd7_qfb_vbe_node ctle_c7_xd7_qfb_vbe_node 0 V=v(xd7.efb)-v(xd7.hpn)
Bctle_c7_xd7_qfb_vce_node ctle_c7_xd7_qfb_vce_node 0 V=v(op7)-v(xd7.efb)
Bctle_c7_xd7_qa0_vbe_node ctle_c7_xd7_qa0_vbe_node 0 V=v(xd7.ea0)-v(xd7.hpp)
Bctle_c7_xd7_qa0_vce_node ctle_c7_xd7_qa0_vce_node 0 V=v(xd7.ca0)-v(xd7.ea0)
Bctle_c7_xd7_qb0_vbe_node ctle_c7_xd7_qb0_vbe_node 0 V=v(xd7.eb0)-v(xd7.hpn)
Bctle_c7_xd7_qb0_vce_node ctle_c7_xd7_qb0_vce_node 0 V=v(xd7.cb0)-v(xd7.eb0)
Bctle_c7_xd7_spa0_vbe_node ctle_c7_xd7_spa0_vbe_node 0 V=v(xd7.ca0)-v(c7k0)
Bctle_c7_xd7_spa0_vce_node ctle_c7_xd7_spa0_vce_node 0 V=v(on7)-v(xd7.ca0)
Bctle_c7_xd7_sna0_vbe_node ctle_c7_xd7_sna0_vbe_node 0 V=v(xd7.ca0)-v(c7k0b)
Bctle_c7_xd7_sna0_vce_node ctle_c7_xd7_sna0_vce_node 0 V=v(op7)-v(xd7.ca0)
Bctle_c7_xd7_spb0_vbe_node ctle_c7_xd7_spb0_vbe_node 0 V=v(xd7.cb0)-v(c7k0)
Bctle_c7_xd7_spb0_vce_node ctle_c7_xd7_spb0_vce_node 0 V=v(op7)-v(xd7.cb0)
Bctle_c7_xd7_snb0_vbe_node ctle_c7_xd7_snb0_vbe_node 0 V=v(xd7.cb0)-v(c7k0b)
Bctle_c7_xd7_snb0_vce_node ctle_c7_xd7_snb0_vce_node 0 V=v(on7)-v(xd7.cb0)
Bctle_c7_xd7_qa1_vbe_node ctle_c7_xd7_qa1_vbe_node 0 V=v(xd7.ea1)-v(xd7.hpp)
Bctle_c7_xd7_qa1_vce_node ctle_c7_xd7_qa1_vce_node 0 V=v(xd7.ca1)-v(xd7.ea1)
Bctle_c7_xd7_qb1_vbe_node ctle_c7_xd7_qb1_vbe_node 0 V=v(xd7.eb1)-v(xd7.hpn)
Bctle_c7_xd7_qb1_vce_node ctle_c7_xd7_qb1_vce_node 0 V=v(xd7.cb1)-v(xd7.eb1)
Bctle_c7_xd7_spa1_vbe_node ctle_c7_xd7_spa1_vbe_node 0 V=v(xd7.ca1)-v(c7k1)
Bctle_c7_xd7_spa1_vce_node ctle_c7_xd7_spa1_vce_node 0 V=v(on7)-v(xd7.ca1)
Bctle_c7_xd7_sna1_vbe_node ctle_c7_xd7_sna1_vbe_node 0 V=v(xd7.ca1)-v(c7k1b)
Bctle_c7_xd7_sna1_vce_node ctle_c7_xd7_sna1_vce_node 0 V=v(op7)-v(xd7.ca1)
Bctle_c7_xd7_spb1_vbe_node ctle_c7_xd7_spb1_vbe_node 0 V=v(xd7.cb1)-v(c7k1)
Bctle_c7_xd7_spb1_vce_node ctle_c7_xd7_spb1_vce_node 0 V=v(op7)-v(xd7.cb1)
Bctle_c7_xd7_snb1_vbe_node ctle_c7_xd7_snb1_vbe_node 0 V=v(xd7.cb1)-v(c7k1b)
Bctle_c7_xd7_snb1_vce_node ctle_c7_xd7_snb1_vce_node 0 V=v(on7)-v(xd7.cb1)
Bctle_c7_xd7_qa2_vbe_node ctle_c7_xd7_qa2_vbe_node 0 V=v(xd7.ea2)-v(xd7.hpp)
Bctle_c7_xd7_qa2_vce_node ctle_c7_xd7_qa2_vce_node 0 V=v(xd7.ca2)-v(xd7.ea2)
Bctle_c7_xd7_qb2_vbe_node ctle_c7_xd7_qb2_vbe_node 0 V=v(xd7.eb2)-v(xd7.hpn)
Bctle_c7_xd7_qb2_vce_node ctle_c7_xd7_qb2_vce_node 0 V=v(xd7.cb2)-v(xd7.eb2)
Bctle_c7_xd7_spa2_vbe_node ctle_c7_xd7_spa2_vbe_node 0 V=v(xd7.ca2)-v(c7k2)
Bctle_c7_xd7_spa2_vce_node ctle_c7_xd7_spa2_vce_node 0 V=v(on7)-v(xd7.ca2)
Bctle_c7_xd7_sna2_vbe_node ctle_c7_xd7_sna2_vbe_node 0 V=v(xd7.ca2)-v(c7k2b)
Bctle_c7_xd7_sna2_vce_node ctle_c7_xd7_sna2_vce_node 0 V=v(op7)-v(xd7.ca2)
Bctle_c7_xd7_spb2_vbe_node ctle_c7_xd7_spb2_vbe_node 0 V=v(xd7.cb2)-v(c7k2)
Bctle_c7_xd7_spb2_vce_node ctle_c7_xd7_spb2_vce_node 0 V=v(op7)-v(xd7.cb2)
Bctle_c7_xd7_snb2_vbe_node ctle_c7_xd7_snb2_vbe_node 0 V=v(xd7.cb2)-v(c7k2b)
Bctle_c7_xd7_snb2_vce_node ctle_c7_xd7_snb2_vce_node 0 V=v(on7)-v(xd7.cb2)
Bocm7 ocm7 0 V=(v(op7)+v(on7))/2
