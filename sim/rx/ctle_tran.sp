* CTLE transient node-stress bench (issue #256): ctle_op's stress cards
* are quiescent (Vip/Vin at dc 0); this bench drives a real differential
* swing so the R3 per-device table gets transient peaks. 16 copies of
* ctle: codes 0-7 at each of two input levels (lo/hi below), same ideal
* source, same placeholder 80 fF load as ctle_ac/ctle_op. Stimulus per
* side (pwl, both polarities): 2 ns settled, 1 ns of 5 GHz alternation
* (200 ps period, 20 ps edges), a 3 ns long run at the opposite polarity,
* then 1 ns of 5 GHz alternation again. Sizing evidence, not a spec
* result.
.include ../../design/rx/netlists/ctle.spice
Vdd vdd 0 1.2
Bvcm vcm 0 V=0.7917*v(vdd)
Vip inp vcm pwl(0n -0.0125 2n -0.0125 2.02n 0.0125 2.1n 0.0125 2.12n -0.0125 2.2n -0.0125 2.22n 0.0125 2.3n 0.0125 2.32n -0.0125 2.4n -0.0125 2.42n 0.0125 2.5n 0.0125 2.52n -0.0125 2.6n -0.0125 2.62n 0.0125 2.7n 0.0125 2.72n -0.0125 2.8n -0.0125 2.82n 0.0125 2.9n 0.0125 2.92n -0.0125 3n -0.0125 3.02n 0.0125 6n 0.0125 6.02n -0.0125 6.1n -0.0125 6.12n 0.0125 6.2n 0.0125 6.22n -0.0125 6.3n -0.0125 6.32n 0.0125 6.4n 0.0125 6.42n -0.0125 6.5n -0.0125 6.52n 0.0125 6.6n 0.0125 6.62n -0.0125 6.7n -0.0125 6.72n 0.0125 6.8n 0.0125 6.82n -0.0125 6.9n -0.0125 6.92n 0.0125 7.1n 0.0125)
Vin inn vcm pwl(0n 0.0125 2n 0.0125 2.02n -0.0125 2.1n -0.0125 2.12n 0.0125 2.2n 0.0125 2.22n -0.0125 2.3n -0.0125 2.32n 0.0125 2.4n 0.0125 2.42n -0.0125 2.5n -0.0125 2.52n 0.0125 2.6n 0.0125 2.62n -0.0125 2.7n -0.0125 2.72n 0.0125 2.8n 0.0125 2.82n -0.0125 2.9n -0.0125 2.92n 0.0125 3n 0.0125 3.02n -0.0125 6n -0.0125 6.02n 0.0125 6.1n 0.0125 6.12n -0.0125 6.2n -0.0125 6.22n 0.0125 6.3n 0.0125 6.32n -0.0125 6.4n -0.0125 6.42n 0.0125 6.5n 0.0125 6.52n -0.0125 6.6n -0.0125 6.62n 0.0125 6.7n 0.0125 6.72n -0.0125 6.8n -0.0125 6.82n 0.0125 6.9n 0.0125 6.92n -0.0125 7.1n -0.0125)
Vjp jnp vcm pwl(0n -0.2 2n -0.2 2.02n 0.2 2.1n 0.2 2.12n -0.2 2.2n -0.2 2.22n 0.2 2.3n 0.2 2.32n -0.2 2.4n -0.2 2.42n 0.2 2.5n 0.2 2.52n -0.2 2.6n -0.2 2.62n 0.2 2.7n 0.2 2.72n -0.2 2.8n -0.2 2.82n 0.2 2.9n 0.2 2.92n -0.2 3n -0.2 3.02n 0.2 6n 0.2 6.02n -0.2 6.1n -0.2 6.12n 0.2 6.2n 0.2 6.22n -0.2 6.3n -0.2 6.32n 0.2 6.4n 0.2 6.42n -0.2 6.5n -0.2 6.52n 0.2 6.6n 0.2 6.62n -0.2 6.7n -0.2 6.72n 0.2 6.8n 0.2 6.82n -0.2 6.9n -0.2 6.92n 0.2 7.1n 0.2)
Vjn jnn vcm pwl(0n 0.2 2n 0.2 2.02n -0.2 2.1n -0.2 2.12n 0.2 2.2n 0.2 2.22n -0.2 2.3n -0.2 2.32n 0.2 2.4n 0.2 2.42n -0.2 2.5n -0.2 2.52n 0.2 2.6n 0.2 2.62n -0.2 2.7n -0.2 2.72n 0.2 2.8n 0.2 2.82n -0.2 2.9n -0.2 2.92n 0.2 3n 0.2 3.02n -0.2 6n -0.2 6.02n 0.2 6.1n 0.2 6.12n -0.2 6.2n -0.2 6.22n 0.2 6.3n 0.2 6.32n -0.2 6.4n -0.2 6.42n 0.2 6.5n 0.2 6.52n -0.2 6.6n -0.2 6.62n 0.2 6.7n 0.2 6.72n -0.2 6.8n -0.2 6.82n 0.2 6.9n 0.2 6.92n -0.2 7.1n -0.2)
Bkl0_0 l0k0 0 V=v(vdd)-0.25
Bkl0_0b l0k0b 0 V=v(vdd)
Bkl0_1 l0k1 0 V=v(vdd)-0.25
Bkl0_1b l0k1b 0 V=v(vdd)
Bkl0_2 l0k2 0 V=v(vdd)-0.25
Bkl0_2b l0k2b 0 V=v(vdd)
Xdl0 inp inn vcm vdd 0 l0k0 l0k0b l0k1 l0k1b l0k2 l0k2b opl0 onl0 ctle
Clpl0 opl0 0 80f
Clnl0 onl0 0 80f
Bdl0 difl0 0 V=v(opl0)-v(onl0)
Bkl1_0 l1k0 0 V=v(vdd)
Bkl1_0b l1k0b 0 V=v(vdd)-0.25
Bkl1_1 l1k1 0 V=v(vdd)-0.25
Bkl1_1b l1k1b 0 V=v(vdd)
Bkl1_2 l1k2 0 V=v(vdd)-0.25
Bkl1_2b l1k2b 0 V=v(vdd)
Xdl1 inp inn vcm vdd 0 l1k0 l1k0b l1k1 l1k1b l1k2 l1k2b opl1 onl1 ctle
Clpl1 opl1 0 80f
Clnl1 onl1 0 80f
Bdl1 difl1 0 V=v(opl1)-v(onl1)
Bkl2_0 l2k0 0 V=v(vdd)-0.25
Bkl2_0b l2k0b 0 V=v(vdd)
Bkl2_1 l2k1 0 V=v(vdd)
Bkl2_1b l2k1b 0 V=v(vdd)-0.25
Bkl2_2 l2k2 0 V=v(vdd)-0.25
Bkl2_2b l2k2b 0 V=v(vdd)
Xdl2 inp inn vcm vdd 0 l2k0 l2k0b l2k1 l2k1b l2k2 l2k2b opl2 onl2 ctle
Clpl2 opl2 0 80f
Clnl2 onl2 0 80f
Bdl2 difl2 0 V=v(opl2)-v(onl2)
Bkl3_0 l3k0 0 V=v(vdd)
Bkl3_0b l3k0b 0 V=v(vdd)-0.25
Bkl3_1 l3k1 0 V=v(vdd)
Bkl3_1b l3k1b 0 V=v(vdd)-0.25
Bkl3_2 l3k2 0 V=v(vdd)-0.25
Bkl3_2b l3k2b 0 V=v(vdd)
Xdl3 inp inn vcm vdd 0 l3k0 l3k0b l3k1 l3k1b l3k2 l3k2b opl3 onl3 ctle
Clpl3 opl3 0 80f
Clnl3 onl3 0 80f
Bdl3 difl3 0 V=v(opl3)-v(onl3)
Bkl4_0 l4k0 0 V=v(vdd)-0.25
Bkl4_0b l4k0b 0 V=v(vdd)
Bkl4_1 l4k1 0 V=v(vdd)-0.25
Bkl4_1b l4k1b 0 V=v(vdd)
Bkl4_2 l4k2 0 V=v(vdd)
Bkl4_2b l4k2b 0 V=v(vdd)-0.25
Xdl4 inp inn vcm vdd 0 l4k0 l4k0b l4k1 l4k1b l4k2 l4k2b opl4 onl4 ctle
Clpl4 opl4 0 80f
Clnl4 onl4 0 80f
Bdl4 difl4 0 V=v(opl4)-v(onl4)
Bkl5_0 l5k0 0 V=v(vdd)
Bkl5_0b l5k0b 0 V=v(vdd)-0.25
Bkl5_1 l5k1 0 V=v(vdd)-0.25
Bkl5_1b l5k1b 0 V=v(vdd)
Bkl5_2 l5k2 0 V=v(vdd)
Bkl5_2b l5k2b 0 V=v(vdd)-0.25
Xdl5 inp inn vcm vdd 0 l5k0 l5k0b l5k1 l5k1b l5k2 l5k2b opl5 onl5 ctle
Clpl5 opl5 0 80f
Clnl5 onl5 0 80f
Bdl5 difl5 0 V=v(opl5)-v(onl5)
Bkl6_0 l6k0 0 V=v(vdd)-0.25
Bkl6_0b l6k0b 0 V=v(vdd)
Bkl6_1 l6k1 0 V=v(vdd)
Bkl6_1b l6k1b 0 V=v(vdd)-0.25
Bkl6_2 l6k2 0 V=v(vdd)
Bkl6_2b l6k2b 0 V=v(vdd)-0.25
Xdl6 inp inn vcm vdd 0 l6k0 l6k0b l6k1 l6k1b l6k2 l6k2b opl6 onl6 ctle
Clpl6 opl6 0 80f
Clnl6 onl6 0 80f
Bdl6 difl6 0 V=v(opl6)-v(onl6)
Bkl7_0 l7k0 0 V=v(vdd)
Bkl7_0b l7k0b 0 V=v(vdd)-0.25
Bkl7_1 l7k1 0 V=v(vdd)
Bkl7_1b l7k1b 0 V=v(vdd)-0.25
Bkl7_2 l7k2 0 V=v(vdd)
Bkl7_2b l7k2b 0 V=v(vdd)-0.25
Xdl7 inp inn vcm vdd 0 l7k0 l7k0b l7k1 l7k1b l7k2 l7k2b opl7 onl7 ctle
Clpl7 opl7 0 80f
Clnl7 onl7 0 80f
Bdl7 difl7 0 V=v(opl7)-v(onl7)
Bkh0_0 h0k0 0 V=v(vdd)-0.25
Bkh0_0b h0k0b 0 V=v(vdd)
Bkh0_1 h0k1 0 V=v(vdd)-0.25
Bkh0_1b h0k1b 0 V=v(vdd)
Bkh0_2 h0k2 0 V=v(vdd)-0.25
Bkh0_2b h0k2b 0 V=v(vdd)
Xdh0 jnp jnn vcm vdd 0 h0k0 h0k0b h0k1 h0k1b h0k2 h0k2b oph0 onh0 ctle
Clph0 oph0 0 80f
Clnh0 onh0 0 80f
Bdh0 difh0 0 V=v(oph0)-v(onh0)
Bkh1_0 h1k0 0 V=v(vdd)
Bkh1_0b h1k0b 0 V=v(vdd)-0.25
Bkh1_1 h1k1 0 V=v(vdd)-0.25
Bkh1_1b h1k1b 0 V=v(vdd)
Bkh1_2 h1k2 0 V=v(vdd)-0.25
Bkh1_2b h1k2b 0 V=v(vdd)
Xdh1 jnp jnn vcm vdd 0 h1k0 h1k0b h1k1 h1k1b h1k2 h1k2b oph1 onh1 ctle
Clph1 oph1 0 80f
Clnh1 onh1 0 80f
Bdh1 difh1 0 V=v(oph1)-v(onh1)
Bkh2_0 h2k0 0 V=v(vdd)-0.25
Bkh2_0b h2k0b 0 V=v(vdd)
Bkh2_1 h2k1 0 V=v(vdd)
Bkh2_1b h2k1b 0 V=v(vdd)-0.25
Bkh2_2 h2k2 0 V=v(vdd)-0.25
Bkh2_2b h2k2b 0 V=v(vdd)
Xdh2 jnp jnn vcm vdd 0 h2k0 h2k0b h2k1 h2k1b h2k2 h2k2b oph2 onh2 ctle
Clph2 oph2 0 80f
Clnh2 onh2 0 80f
Bdh2 difh2 0 V=v(oph2)-v(onh2)
Bkh3_0 h3k0 0 V=v(vdd)
Bkh3_0b h3k0b 0 V=v(vdd)-0.25
Bkh3_1 h3k1 0 V=v(vdd)
Bkh3_1b h3k1b 0 V=v(vdd)-0.25
Bkh3_2 h3k2 0 V=v(vdd)-0.25
Bkh3_2b h3k2b 0 V=v(vdd)
Xdh3 jnp jnn vcm vdd 0 h3k0 h3k0b h3k1 h3k1b h3k2 h3k2b oph3 onh3 ctle
Clph3 oph3 0 80f
Clnh3 onh3 0 80f
Bdh3 difh3 0 V=v(oph3)-v(onh3)
Bkh4_0 h4k0 0 V=v(vdd)-0.25
Bkh4_0b h4k0b 0 V=v(vdd)
Bkh4_1 h4k1 0 V=v(vdd)-0.25
Bkh4_1b h4k1b 0 V=v(vdd)
Bkh4_2 h4k2 0 V=v(vdd)
Bkh4_2b h4k2b 0 V=v(vdd)-0.25
Xdh4 jnp jnn vcm vdd 0 h4k0 h4k0b h4k1 h4k1b h4k2 h4k2b oph4 onh4 ctle
Clph4 oph4 0 80f
Clnh4 onh4 0 80f
Bdh4 difh4 0 V=v(oph4)-v(onh4)
Bkh5_0 h5k0 0 V=v(vdd)
Bkh5_0b h5k0b 0 V=v(vdd)-0.25
Bkh5_1 h5k1 0 V=v(vdd)-0.25
Bkh5_1b h5k1b 0 V=v(vdd)
Bkh5_2 h5k2 0 V=v(vdd)
Bkh5_2b h5k2b 0 V=v(vdd)-0.25
Xdh5 jnp jnn vcm vdd 0 h5k0 h5k0b h5k1 h5k1b h5k2 h5k2b oph5 onh5 ctle
Clph5 oph5 0 80f
Clnh5 onh5 0 80f
Bdh5 difh5 0 V=v(oph5)-v(onh5)
Bkh6_0 h6k0 0 V=v(vdd)-0.25
Bkh6_0b h6k0b 0 V=v(vdd)
Bkh6_1 h6k1 0 V=v(vdd)
Bkh6_1b h6k1b 0 V=v(vdd)-0.25
Bkh6_2 h6k2 0 V=v(vdd)
Bkh6_2b h6k2b 0 V=v(vdd)-0.25
Xdh6 jnp jnn vcm vdd 0 h6k0 h6k0b h6k1 h6k1b h6k2 h6k2b oph6 onh6 ctle
Clph6 oph6 0 80f
Clnh6 onh6 0 80f
Bdh6 difh6 0 V=v(oph6)-v(onh6)
Bkh7_0 h7k0 0 V=v(vdd)
Bkh7_0b h7k0b 0 V=v(vdd)-0.25
Bkh7_1 h7k1 0 V=v(vdd)
Bkh7_1b h7k1b 0 V=v(vdd)-0.25
Bkh7_2 h7k2 0 V=v(vdd)
Bkh7_2b h7k2b 0 V=v(vdd)-0.25
Xdh7 jnp jnn vcm vdd 0 h7k0 h7k0b h7k1 h7k1b h7k2 h7k2b oph7 onh7 ctle
Clph7 oph7 0 80f
Clnh7 onh7 0 80f
Bdh7 difh7 0 V=v(oph7)-v(onh7)
Bctle_lo_c0_xdl0_q1_vbe_node ctle_lo_c0_xdl0_q1_vbe_node 0 V=v(xdl0.e1)-v(inp)
Bctle_lo_c0_xdl0_q1_vce_node ctle_lo_c0_xdl0_q1_vce_node 0 V=v(onl0)-v(xdl0.e1)
Bctle_lo_c0_xdl0_q2_vbe_node ctle_lo_c0_xdl0_q2_vbe_node 0 V=v(xdl0.e2)-v(inn)
Bctle_lo_c0_xdl0_q2_vce_node ctle_lo_c0_xdl0_q2_vce_node 0 V=v(opl0)-v(xdl0.e2)
Bctle_lo_c0_xdl0_qfa_vbe_node ctle_lo_c0_xdl0_qfa_vbe_node 0 V=v(xdl0.efa)-v(xdl0.hpp)
Bctle_lo_c0_xdl0_qfa_vce_node ctle_lo_c0_xdl0_qfa_vce_node 0 V=v(onl0)-v(xdl0.efa)
Bctle_lo_c0_xdl0_qfb_vbe_node ctle_lo_c0_xdl0_qfb_vbe_node 0 V=v(xdl0.efb)-v(xdl0.hpn)
Bctle_lo_c0_xdl0_qfb_vce_node ctle_lo_c0_xdl0_qfb_vce_node 0 V=v(opl0)-v(xdl0.efb)
Bctle_lo_c0_xdl0_qa0_vbe_node ctle_lo_c0_xdl0_qa0_vbe_node 0 V=v(xdl0.ea0)-v(xdl0.hpp)
Bctle_lo_c0_xdl0_qa0_vce_node ctle_lo_c0_xdl0_qa0_vce_node 0 V=v(xdl0.ca0)-v(xdl0.ea0)
Bctle_lo_c0_xdl0_qb0_vbe_node ctle_lo_c0_xdl0_qb0_vbe_node 0 V=v(xdl0.eb0)-v(xdl0.hpn)
Bctle_lo_c0_xdl0_qb0_vce_node ctle_lo_c0_xdl0_qb0_vce_node 0 V=v(xdl0.cb0)-v(xdl0.eb0)
Bctle_lo_c0_xdl0_spa0_vbe_node ctle_lo_c0_xdl0_spa0_vbe_node 0 V=v(xdl0.ca0)-v(l0k0)
Bctle_lo_c0_xdl0_spa0_vce_node ctle_lo_c0_xdl0_spa0_vce_node 0 V=v(onl0)-v(xdl0.ca0)
Bctle_lo_c0_xdl0_sna0_vbe_node ctle_lo_c0_xdl0_sna0_vbe_node 0 V=v(xdl0.ca0)-v(l0k0b)
Bctle_lo_c0_xdl0_sna0_vce_node ctle_lo_c0_xdl0_sna0_vce_node 0 V=v(opl0)-v(xdl0.ca0)
Bctle_lo_c0_xdl0_spb0_vbe_node ctle_lo_c0_xdl0_spb0_vbe_node 0 V=v(xdl0.cb0)-v(l0k0)
Bctle_lo_c0_xdl0_spb0_vce_node ctle_lo_c0_xdl0_spb0_vce_node 0 V=v(opl0)-v(xdl0.cb0)
Bctle_lo_c0_xdl0_snb0_vbe_node ctle_lo_c0_xdl0_snb0_vbe_node 0 V=v(xdl0.cb0)-v(l0k0b)
Bctle_lo_c0_xdl0_snb0_vce_node ctle_lo_c0_xdl0_snb0_vce_node 0 V=v(onl0)-v(xdl0.cb0)
Bctle_lo_c0_xdl0_qa1_vbe_node ctle_lo_c0_xdl0_qa1_vbe_node 0 V=v(xdl0.ea1)-v(xdl0.hpp)
Bctle_lo_c0_xdl0_qa1_vce_node ctle_lo_c0_xdl0_qa1_vce_node 0 V=v(xdl0.ca1)-v(xdl0.ea1)
Bctle_lo_c0_xdl0_qb1_vbe_node ctle_lo_c0_xdl0_qb1_vbe_node 0 V=v(xdl0.eb1)-v(xdl0.hpn)
Bctle_lo_c0_xdl0_qb1_vce_node ctle_lo_c0_xdl0_qb1_vce_node 0 V=v(xdl0.cb1)-v(xdl0.eb1)
Bctle_lo_c0_xdl0_spa1_vbe_node ctle_lo_c0_xdl0_spa1_vbe_node 0 V=v(xdl0.ca1)-v(l0k1)
Bctle_lo_c0_xdl0_spa1_vce_node ctle_lo_c0_xdl0_spa1_vce_node 0 V=v(onl0)-v(xdl0.ca1)
Bctle_lo_c0_xdl0_sna1_vbe_node ctle_lo_c0_xdl0_sna1_vbe_node 0 V=v(xdl0.ca1)-v(l0k1b)
Bctle_lo_c0_xdl0_sna1_vce_node ctle_lo_c0_xdl0_sna1_vce_node 0 V=v(opl0)-v(xdl0.ca1)
Bctle_lo_c0_xdl0_spb1_vbe_node ctle_lo_c0_xdl0_spb1_vbe_node 0 V=v(xdl0.cb1)-v(l0k1)
Bctle_lo_c0_xdl0_spb1_vce_node ctle_lo_c0_xdl0_spb1_vce_node 0 V=v(opl0)-v(xdl0.cb1)
Bctle_lo_c0_xdl0_snb1_vbe_node ctle_lo_c0_xdl0_snb1_vbe_node 0 V=v(xdl0.cb1)-v(l0k1b)
Bctle_lo_c0_xdl0_snb1_vce_node ctle_lo_c0_xdl0_snb1_vce_node 0 V=v(onl0)-v(xdl0.cb1)
Bctle_lo_c0_xdl0_qa2_vbe_node ctle_lo_c0_xdl0_qa2_vbe_node 0 V=v(xdl0.ea2)-v(xdl0.hpp)
Bctle_lo_c0_xdl0_qa2_vce_node ctle_lo_c0_xdl0_qa2_vce_node 0 V=v(xdl0.ca2)-v(xdl0.ea2)
Bctle_lo_c0_xdl0_qb2_vbe_node ctle_lo_c0_xdl0_qb2_vbe_node 0 V=v(xdl0.eb2)-v(xdl0.hpn)
Bctle_lo_c0_xdl0_qb2_vce_node ctle_lo_c0_xdl0_qb2_vce_node 0 V=v(xdl0.cb2)-v(xdl0.eb2)
Bctle_lo_c0_xdl0_spa2_vbe_node ctle_lo_c0_xdl0_spa2_vbe_node 0 V=v(xdl0.ca2)-v(l0k2)
Bctle_lo_c0_xdl0_spa2_vce_node ctle_lo_c0_xdl0_spa2_vce_node 0 V=v(onl0)-v(xdl0.ca2)
Bctle_lo_c0_xdl0_sna2_vbe_node ctle_lo_c0_xdl0_sna2_vbe_node 0 V=v(xdl0.ca2)-v(l0k2b)
Bctle_lo_c0_xdl0_sna2_vce_node ctle_lo_c0_xdl0_sna2_vce_node 0 V=v(opl0)-v(xdl0.ca2)
Bctle_lo_c0_xdl0_spb2_vbe_node ctle_lo_c0_xdl0_spb2_vbe_node 0 V=v(xdl0.cb2)-v(l0k2)
Bctle_lo_c0_xdl0_spb2_vce_node ctle_lo_c0_xdl0_spb2_vce_node 0 V=v(opl0)-v(xdl0.cb2)
Bctle_lo_c0_xdl0_snb2_vbe_node ctle_lo_c0_xdl0_snb2_vbe_node 0 V=v(xdl0.cb2)-v(l0k2b)
Bctle_lo_c0_xdl0_snb2_vce_node ctle_lo_c0_xdl0_snb2_vce_node 0 V=v(onl0)-v(xdl0.cb2)
Bctle_lo_c1_xdl1_q1_vbe_node ctle_lo_c1_xdl1_q1_vbe_node 0 V=v(xdl1.e1)-v(inp)
Bctle_lo_c1_xdl1_q1_vce_node ctle_lo_c1_xdl1_q1_vce_node 0 V=v(onl1)-v(xdl1.e1)
Bctle_lo_c1_xdl1_q2_vbe_node ctle_lo_c1_xdl1_q2_vbe_node 0 V=v(xdl1.e2)-v(inn)
Bctle_lo_c1_xdl1_q2_vce_node ctle_lo_c1_xdl1_q2_vce_node 0 V=v(opl1)-v(xdl1.e2)
Bctle_lo_c1_xdl1_qfa_vbe_node ctle_lo_c1_xdl1_qfa_vbe_node 0 V=v(xdl1.efa)-v(xdl1.hpp)
Bctle_lo_c1_xdl1_qfa_vce_node ctle_lo_c1_xdl1_qfa_vce_node 0 V=v(onl1)-v(xdl1.efa)
Bctle_lo_c1_xdl1_qfb_vbe_node ctle_lo_c1_xdl1_qfb_vbe_node 0 V=v(xdl1.efb)-v(xdl1.hpn)
Bctle_lo_c1_xdl1_qfb_vce_node ctle_lo_c1_xdl1_qfb_vce_node 0 V=v(opl1)-v(xdl1.efb)
Bctle_lo_c1_xdl1_qa0_vbe_node ctle_lo_c1_xdl1_qa0_vbe_node 0 V=v(xdl1.ea0)-v(xdl1.hpp)
Bctle_lo_c1_xdl1_qa0_vce_node ctle_lo_c1_xdl1_qa0_vce_node 0 V=v(xdl1.ca0)-v(xdl1.ea0)
Bctle_lo_c1_xdl1_qb0_vbe_node ctle_lo_c1_xdl1_qb0_vbe_node 0 V=v(xdl1.eb0)-v(xdl1.hpn)
Bctle_lo_c1_xdl1_qb0_vce_node ctle_lo_c1_xdl1_qb0_vce_node 0 V=v(xdl1.cb0)-v(xdl1.eb0)
Bctle_lo_c1_xdl1_spa0_vbe_node ctle_lo_c1_xdl1_spa0_vbe_node 0 V=v(xdl1.ca0)-v(l1k0)
Bctle_lo_c1_xdl1_spa0_vce_node ctle_lo_c1_xdl1_spa0_vce_node 0 V=v(onl1)-v(xdl1.ca0)
Bctle_lo_c1_xdl1_sna0_vbe_node ctle_lo_c1_xdl1_sna0_vbe_node 0 V=v(xdl1.ca0)-v(l1k0b)
Bctle_lo_c1_xdl1_sna0_vce_node ctle_lo_c1_xdl1_sna0_vce_node 0 V=v(opl1)-v(xdl1.ca0)
Bctle_lo_c1_xdl1_spb0_vbe_node ctle_lo_c1_xdl1_spb0_vbe_node 0 V=v(xdl1.cb0)-v(l1k0)
Bctle_lo_c1_xdl1_spb0_vce_node ctle_lo_c1_xdl1_spb0_vce_node 0 V=v(opl1)-v(xdl1.cb0)
Bctle_lo_c1_xdl1_snb0_vbe_node ctle_lo_c1_xdl1_snb0_vbe_node 0 V=v(xdl1.cb0)-v(l1k0b)
Bctle_lo_c1_xdl1_snb0_vce_node ctle_lo_c1_xdl1_snb0_vce_node 0 V=v(onl1)-v(xdl1.cb0)
Bctle_lo_c1_xdl1_qa1_vbe_node ctle_lo_c1_xdl1_qa1_vbe_node 0 V=v(xdl1.ea1)-v(xdl1.hpp)
Bctle_lo_c1_xdl1_qa1_vce_node ctle_lo_c1_xdl1_qa1_vce_node 0 V=v(xdl1.ca1)-v(xdl1.ea1)
Bctle_lo_c1_xdl1_qb1_vbe_node ctle_lo_c1_xdl1_qb1_vbe_node 0 V=v(xdl1.eb1)-v(xdl1.hpn)
Bctle_lo_c1_xdl1_qb1_vce_node ctle_lo_c1_xdl1_qb1_vce_node 0 V=v(xdl1.cb1)-v(xdl1.eb1)
Bctle_lo_c1_xdl1_spa1_vbe_node ctle_lo_c1_xdl1_spa1_vbe_node 0 V=v(xdl1.ca1)-v(l1k1)
Bctle_lo_c1_xdl1_spa1_vce_node ctle_lo_c1_xdl1_spa1_vce_node 0 V=v(onl1)-v(xdl1.ca1)
Bctle_lo_c1_xdl1_sna1_vbe_node ctle_lo_c1_xdl1_sna1_vbe_node 0 V=v(xdl1.ca1)-v(l1k1b)
Bctle_lo_c1_xdl1_sna1_vce_node ctle_lo_c1_xdl1_sna1_vce_node 0 V=v(opl1)-v(xdl1.ca1)
Bctle_lo_c1_xdl1_spb1_vbe_node ctle_lo_c1_xdl1_spb1_vbe_node 0 V=v(xdl1.cb1)-v(l1k1)
Bctle_lo_c1_xdl1_spb1_vce_node ctle_lo_c1_xdl1_spb1_vce_node 0 V=v(opl1)-v(xdl1.cb1)
Bctle_lo_c1_xdl1_snb1_vbe_node ctle_lo_c1_xdl1_snb1_vbe_node 0 V=v(xdl1.cb1)-v(l1k1b)
Bctle_lo_c1_xdl1_snb1_vce_node ctle_lo_c1_xdl1_snb1_vce_node 0 V=v(onl1)-v(xdl1.cb1)
Bctle_lo_c1_xdl1_qa2_vbe_node ctle_lo_c1_xdl1_qa2_vbe_node 0 V=v(xdl1.ea2)-v(xdl1.hpp)
Bctle_lo_c1_xdl1_qa2_vce_node ctle_lo_c1_xdl1_qa2_vce_node 0 V=v(xdl1.ca2)-v(xdl1.ea2)
Bctle_lo_c1_xdl1_qb2_vbe_node ctle_lo_c1_xdl1_qb2_vbe_node 0 V=v(xdl1.eb2)-v(xdl1.hpn)
Bctle_lo_c1_xdl1_qb2_vce_node ctle_lo_c1_xdl1_qb2_vce_node 0 V=v(xdl1.cb2)-v(xdl1.eb2)
Bctle_lo_c1_xdl1_spa2_vbe_node ctle_lo_c1_xdl1_spa2_vbe_node 0 V=v(xdl1.ca2)-v(l1k2)
Bctle_lo_c1_xdl1_spa2_vce_node ctle_lo_c1_xdl1_spa2_vce_node 0 V=v(onl1)-v(xdl1.ca2)
Bctle_lo_c1_xdl1_sna2_vbe_node ctle_lo_c1_xdl1_sna2_vbe_node 0 V=v(xdl1.ca2)-v(l1k2b)
Bctle_lo_c1_xdl1_sna2_vce_node ctle_lo_c1_xdl1_sna2_vce_node 0 V=v(opl1)-v(xdl1.ca2)
Bctle_lo_c1_xdl1_spb2_vbe_node ctle_lo_c1_xdl1_spb2_vbe_node 0 V=v(xdl1.cb2)-v(l1k2)
Bctle_lo_c1_xdl1_spb2_vce_node ctle_lo_c1_xdl1_spb2_vce_node 0 V=v(opl1)-v(xdl1.cb2)
Bctle_lo_c1_xdl1_snb2_vbe_node ctle_lo_c1_xdl1_snb2_vbe_node 0 V=v(xdl1.cb2)-v(l1k2b)
Bctle_lo_c1_xdl1_snb2_vce_node ctle_lo_c1_xdl1_snb2_vce_node 0 V=v(onl1)-v(xdl1.cb2)
Bctle_lo_c2_xdl2_q1_vbe_node ctle_lo_c2_xdl2_q1_vbe_node 0 V=v(xdl2.e1)-v(inp)
Bctle_lo_c2_xdl2_q1_vce_node ctle_lo_c2_xdl2_q1_vce_node 0 V=v(onl2)-v(xdl2.e1)
Bctle_lo_c2_xdl2_q2_vbe_node ctle_lo_c2_xdl2_q2_vbe_node 0 V=v(xdl2.e2)-v(inn)
Bctle_lo_c2_xdl2_q2_vce_node ctle_lo_c2_xdl2_q2_vce_node 0 V=v(opl2)-v(xdl2.e2)
Bctle_lo_c2_xdl2_qfa_vbe_node ctle_lo_c2_xdl2_qfa_vbe_node 0 V=v(xdl2.efa)-v(xdl2.hpp)
Bctle_lo_c2_xdl2_qfa_vce_node ctle_lo_c2_xdl2_qfa_vce_node 0 V=v(onl2)-v(xdl2.efa)
Bctle_lo_c2_xdl2_qfb_vbe_node ctle_lo_c2_xdl2_qfb_vbe_node 0 V=v(xdl2.efb)-v(xdl2.hpn)
Bctle_lo_c2_xdl2_qfb_vce_node ctle_lo_c2_xdl2_qfb_vce_node 0 V=v(opl2)-v(xdl2.efb)
Bctle_lo_c2_xdl2_qa0_vbe_node ctle_lo_c2_xdl2_qa0_vbe_node 0 V=v(xdl2.ea0)-v(xdl2.hpp)
Bctle_lo_c2_xdl2_qa0_vce_node ctle_lo_c2_xdl2_qa0_vce_node 0 V=v(xdl2.ca0)-v(xdl2.ea0)
Bctle_lo_c2_xdl2_qb0_vbe_node ctle_lo_c2_xdl2_qb0_vbe_node 0 V=v(xdl2.eb0)-v(xdl2.hpn)
Bctle_lo_c2_xdl2_qb0_vce_node ctle_lo_c2_xdl2_qb0_vce_node 0 V=v(xdl2.cb0)-v(xdl2.eb0)
Bctle_lo_c2_xdl2_spa0_vbe_node ctle_lo_c2_xdl2_spa0_vbe_node 0 V=v(xdl2.ca0)-v(l2k0)
Bctle_lo_c2_xdl2_spa0_vce_node ctle_lo_c2_xdl2_spa0_vce_node 0 V=v(onl2)-v(xdl2.ca0)
Bctle_lo_c2_xdl2_sna0_vbe_node ctle_lo_c2_xdl2_sna0_vbe_node 0 V=v(xdl2.ca0)-v(l2k0b)
Bctle_lo_c2_xdl2_sna0_vce_node ctle_lo_c2_xdl2_sna0_vce_node 0 V=v(opl2)-v(xdl2.ca0)
Bctle_lo_c2_xdl2_spb0_vbe_node ctle_lo_c2_xdl2_spb0_vbe_node 0 V=v(xdl2.cb0)-v(l2k0)
Bctle_lo_c2_xdl2_spb0_vce_node ctle_lo_c2_xdl2_spb0_vce_node 0 V=v(opl2)-v(xdl2.cb0)
Bctle_lo_c2_xdl2_snb0_vbe_node ctle_lo_c2_xdl2_snb0_vbe_node 0 V=v(xdl2.cb0)-v(l2k0b)
Bctle_lo_c2_xdl2_snb0_vce_node ctle_lo_c2_xdl2_snb0_vce_node 0 V=v(onl2)-v(xdl2.cb0)
Bctle_lo_c2_xdl2_qa1_vbe_node ctle_lo_c2_xdl2_qa1_vbe_node 0 V=v(xdl2.ea1)-v(xdl2.hpp)
Bctle_lo_c2_xdl2_qa1_vce_node ctle_lo_c2_xdl2_qa1_vce_node 0 V=v(xdl2.ca1)-v(xdl2.ea1)
Bctle_lo_c2_xdl2_qb1_vbe_node ctle_lo_c2_xdl2_qb1_vbe_node 0 V=v(xdl2.eb1)-v(xdl2.hpn)
Bctle_lo_c2_xdl2_qb1_vce_node ctle_lo_c2_xdl2_qb1_vce_node 0 V=v(xdl2.cb1)-v(xdl2.eb1)
Bctle_lo_c2_xdl2_spa1_vbe_node ctle_lo_c2_xdl2_spa1_vbe_node 0 V=v(xdl2.ca1)-v(l2k1)
Bctle_lo_c2_xdl2_spa1_vce_node ctle_lo_c2_xdl2_spa1_vce_node 0 V=v(onl2)-v(xdl2.ca1)
Bctle_lo_c2_xdl2_sna1_vbe_node ctle_lo_c2_xdl2_sna1_vbe_node 0 V=v(xdl2.ca1)-v(l2k1b)
Bctle_lo_c2_xdl2_sna1_vce_node ctle_lo_c2_xdl2_sna1_vce_node 0 V=v(opl2)-v(xdl2.ca1)
Bctle_lo_c2_xdl2_spb1_vbe_node ctle_lo_c2_xdl2_spb1_vbe_node 0 V=v(xdl2.cb1)-v(l2k1)
Bctle_lo_c2_xdl2_spb1_vce_node ctle_lo_c2_xdl2_spb1_vce_node 0 V=v(opl2)-v(xdl2.cb1)
Bctle_lo_c2_xdl2_snb1_vbe_node ctle_lo_c2_xdl2_snb1_vbe_node 0 V=v(xdl2.cb1)-v(l2k1b)
Bctle_lo_c2_xdl2_snb1_vce_node ctle_lo_c2_xdl2_snb1_vce_node 0 V=v(onl2)-v(xdl2.cb1)
Bctle_lo_c2_xdl2_qa2_vbe_node ctle_lo_c2_xdl2_qa2_vbe_node 0 V=v(xdl2.ea2)-v(xdl2.hpp)
Bctle_lo_c2_xdl2_qa2_vce_node ctle_lo_c2_xdl2_qa2_vce_node 0 V=v(xdl2.ca2)-v(xdl2.ea2)
Bctle_lo_c2_xdl2_qb2_vbe_node ctle_lo_c2_xdl2_qb2_vbe_node 0 V=v(xdl2.eb2)-v(xdl2.hpn)
Bctle_lo_c2_xdl2_qb2_vce_node ctle_lo_c2_xdl2_qb2_vce_node 0 V=v(xdl2.cb2)-v(xdl2.eb2)
Bctle_lo_c2_xdl2_spa2_vbe_node ctle_lo_c2_xdl2_spa2_vbe_node 0 V=v(xdl2.ca2)-v(l2k2)
Bctle_lo_c2_xdl2_spa2_vce_node ctle_lo_c2_xdl2_spa2_vce_node 0 V=v(onl2)-v(xdl2.ca2)
Bctle_lo_c2_xdl2_sna2_vbe_node ctle_lo_c2_xdl2_sna2_vbe_node 0 V=v(xdl2.ca2)-v(l2k2b)
Bctle_lo_c2_xdl2_sna2_vce_node ctle_lo_c2_xdl2_sna2_vce_node 0 V=v(opl2)-v(xdl2.ca2)
Bctle_lo_c2_xdl2_spb2_vbe_node ctle_lo_c2_xdl2_spb2_vbe_node 0 V=v(xdl2.cb2)-v(l2k2)
Bctle_lo_c2_xdl2_spb2_vce_node ctle_lo_c2_xdl2_spb2_vce_node 0 V=v(opl2)-v(xdl2.cb2)
Bctle_lo_c2_xdl2_snb2_vbe_node ctle_lo_c2_xdl2_snb2_vbe_node 0 V=v(xdl2.cb2)-v(l2k2b)
Bctle_lo_c2_xdl2_snb2_vce_node ctle_lo_c2_xdl2_snb2_vce_node 0 V=v(onl2)-v(xdl2.cb2)
Bctle_lo_c3_xdl3_q1_vbe_node ctle_lo_c3_xdl3_q1_vbe_node 0 V=v(xdl3.e1)-v(inp)
Bctle_lo_c3_xdl3_q1_vce_node ctle_lo_c3_xdl3_q1_vce_node 0 V=v(onl3)-v(xdl3.e1)
Bctle_lo_c3_xdl3_q2_vbe_node ctle_lo_c3_xdl3_q2_vbe_node 0 V=v(xdl3.e2)-v(inn)
Bctle_lo_c3_xdl3_q2_vce_node ctle_lo_c3_xdl3_q2_vce_node 0 V=v(opl3)-v(xdl3.e2)
Bctle_lo_c3_xdl3_qfa_vbe_node ctle_lo_c3_xdl3_qfa_vbe_node 0 V=v(xdl3.efa)-v(xdl3.hpp)
Bctle_lo_c3_xdl3_qfa_vce_node ctle_lo_c3_xdl3_qfa_vce_node 0 V=v(onl3)-v(xdl3.efa)
Bctle_lo_c3_xdl3_qfb_vbe_node ctle_lo_c3_xdl3_qfb_vbe_node 0 V=v(xdl3.efb)-v(xdl3.hpn)
Bctle_lo_c3_xdl3_qfb_vce_node ctle_lo_c3_xdl3_qfb_vce_node 0 V=v(opl3)-v(xdl3.efb)
Bctle_lo_c3_xdl3_qa0_vbe_node ctle_lo_c3_xdl3_qa0_vbe_node 0 V=v(xdl3.ea0)-v(xdl3.hpp)
Bctle_lo_c3_xdl3_qa0_vce_node ctle_lo_c3_xdl3_qa0_vce_node 0 V=v(xdl3.ca0)-v(xdl3.ea0)
Bctle_lo_c3_xdl3_qb0_vbe_node ctle_lo_c3_xdl3_qb0_vbe_node 0 V=v(xdl3.eb0)-v(xdl3.hpn)
Bctle_lo_c3_xdl3_qb0_vce_node ctle_lo_c3_xdl3_qb0_vce_node 0 V=v(xdl3.cb0)-v(xdl3.eb0)
Bctle_lo_c3_xdl3_spa0_vbe_node ctle_lo_c3_xdl3_spa0_vbe_node 0 V=v(xdl3.ca0)-v(l3k0)
Bctle_lo_c3_xdl3_spa0_vce_node ctle_lo_c3_xdl3_spa0_vce_node 0 V=v(onl3)-v(xdl3.ca0)
Bctle_lo_c3_xdl3_sna0_vbe_node ctle_lo_c3_xdl3_sna0_vbe_node 0 V=v(xdl3.ca0)-v(l3k0b)
Bctle_lo_c3_xdl3_sna0_vce_node ctle_lo_c3_xdl3_sna0_vce_node 0 V=v(opl3)-v(xdl3.ca0)
Bctle_lo_c3_xdl3_spb0_vbe_node ctle_lo_c3_xdl3_spb0_vbe_node 0 V=v(xdl3.cb0)-v(l3k0)
Bctle_lo_c3_xdl3_spb0_vce_node ctle_lo_c3_xdl3_spb0_vce_node 0 V=v(opl3)-v(xdl3.cb0)
Bctle_lo_c3_xdl3_snb0_vbe_node ctle_lo_c3_xdl3_snb0_vbe_node 0 V=v(xdl3.cb0)-v(l3k0b)
Bctle_lo_c3_xdl3_snb0_vce_node ctle_lo_c3_xdl3_snb0_vce_node 0 V=v(onl3)-v(xdl3.cb0)
Bctle_lo_c3_xdl3_qa1_vbe_node ctle_lo_c3_xdl3_qa1_vbe_node 0 V=v(xdl3.ea1)-v(xdl3.hpp)
Bctle_lo_c3_xdl3_qa1_vce_node ctle_lo_c3_xdl3_qa1_vce_node 0 V=v(xdl3.ca1)-v(xdl3.ea1)
Bctle_lo_c3_xdl3_qb1_vbe_node ctle_lo_c3_xdl3_qb1_vbe_node 0 V=v(xdl3.eb1)-v(xdl3.hpn)
Bctle_lo_c3_xdl3_qb1_vce_node ctle_lo_c3_xdl3_qb1_vce_node 0 V=v(xdl3.cb1)-v(xdl3.eb1)
Bctle_lo_c3_xdl3_spa1_vbe_node ctle_lo_c3_xdl3_spa1_vbe_node 0 V=v(xdl3.ca1)-v(l3k1)
Bctle_lo_c3_xdl3_spa1_vce_node ctle_lo_c3_xdl3_spa1_vce_node 0 V=v(onl3)-v(xdl3.ca1)
Bctle_lo_c3_xdl3_sna1_vbe_node ctle_lo_c3_xdl3_sna1_vbe_node 0 V=v(xdl3.ca1)-v(l3k1b)
Bctle_lo_c3_xdl3_sna1_vce_node ctle_lo_c3_xdl3_sna1_vce_node 0 V=v(opl3)-v(xdl3.ca1)
Bctle_lo_c3_xdl3_spb1_vbe_node ctle_lo_c3_xdl3_spb1_vbe_node 0 V=v(xdl3.cb1)-v(l3k1)
Bctle_lo_c3_xdl3_spb1_vce_node ctle_lo_c3_xdl3_spb1_vce_node 0 V=v(opl3)-v(xdl3.cb1)
Bctle_lo_c3_xdl3_snb1_vbe_node ctle_lo_c3_xdl3_snb1_vbe_node 0 V=v(xdl3.cb1)-v(l3k1b)
Bctle_lo_c3_xdl3_snb1_vce_node ctle_lo_c3_xdl3_snb1_vce_node 0 V=v(onl3)-v(xdl3.cb1)
Bctle_lo_c3_xdl3_qa2_vbe_node ctle_lo_c3_xdl3_qa2_vbe_node 0 V=v(xdl3.ea2)-v(xdl3.hpp)
Bctle_lo_c3_xdl3_qa2_vce_node ctle_lo_c3_xdl3_qa2_vce_node 0 V=v(xdl3.ca2)-v(xdl3.ea2)
Bctle_lo_c3_xdl3_qb2_vbe_node ctle_lo_c3_xdl3_qb2_vbe_node 0 V=v(xdl3.eb2)-v(xdl3.hpn)
Bctle_lo_c3_xdl3_qb2_vce_node ctle_lo_c3_xdl3_qb2_vce_node 0 V=v(xdl3.cb2)-v(xdl3.eb2)
Bctle_lo_c3_xdl3_spa2_vbe_node ctle_lo_c3_xdl3_spa2_vbe_node 0 V=v(xdl3.ca2)-v(l3k2)
Bctle_lo_c3_xdl3_spa2_vce_node ctle_lo_c3_xdl3_spa2_vce_node 0 V=v(onl3)-v(xdl3.ca2)
Bctle_lo_c3_xdl3_sna2_vbe_node ctle_lo_c3_xdl3_sna2_vbe_node 0 V=v(xdl3.ca2)-v(l3k2b)
Bctle_lo_c3_xdl3_sna2_vce_node ctle_lo_c3_xdl3_sna2_vce_node 0 V=v(opl3)-v(xdl3.ca2)
Bctle_lo_c3_xdl3_spb2_vbe_node ctle_lo_c3_xdl3_spb2_vbe_node 0 V=v(xdl3.cb2)-v(l3k2)
Bctle_lo_c3_xdl3_spb2_vce_node ctle_lo_c3_xdl3_spb2_vce_node 0 V=v(opl3)-v(xdl3.cb2)
Bctle_lo_c3_xdl3_snb2_vbe_node ctle_lo_c3_xdl3_snb2_vbe_node 0 V=v(xdl3.cb2)-v(l3k2b)
Bctle_lo_c3_xdl3_snb2_vce_node ctle_lo_c3_xdl3_snb2_vce_node 0 V=v(onl3)-v(xdl3.cb2)
Bctle_lo_c4_xdl4_q1_vbe_node ctle_lo_c4_xdl4_q1_vbe_node 0 V=v(xdl4.e1)-v(inp)
Bctle_lo_c4_xdl4_q1_vce_node ctle_lo_c4_xdl4_q1_vce_node 0 V=v(onl4)-v(xdl4.e1)
Bctle_lo_c4_xdl4_q2_vbe_node ctle_lo_c4_xdl4_q2_vbe_node 0 V=v(xdl4.e2)-v(inn)
Bctle_lo_c4_xdl4_q2_vce_node ctle_lo_c4_xdl4_q2_vce_node 0 V=v(opl4)-v(xdl4.e2)
Bctle_lo_c4_xdl4_qfa_vbe_node ctle_lo_c4_xdl4_qfa_vbe_node 0 V=v(xdl4.efa)-v(xdl4.hpp)
Bctle_lo_c4_xdl4_qfa_vce_node ctle_lo_c4_xdl4_qfa_vce_node 0 V=v(onl4)-v(xdl4.efa)
Bctle_lo_c4_xdl4_qfb_vbe_node ctle_lo_c4_xdl4_qfb_vbe_node 0 V=v(xdl4.efb)-v(xdl4.hpn)
Bctle_lo_c4_xdl4_qfb_vce_node ctle_lo_c4_xdl4_qfb_vce_node 0 V=v(opl4)-v(xdl4.efb)
Bctle_lo_c4_xdl4_qa0_vbe_node ctle_lo_c4_xdl4_qa0_vbe_node 0 V=v(xdl4.ea0)-v(xdl4.hpp)
Bctle_lo_c4_xdl4_qa0_vce_node ctle_lo_c4_xdl4_qa0_vce_node 0 V=v(xdl4.ca0)-v(xdl4.ea0)
Bctle_lo_c4_xdl4_qb0_vbe_node ctle_lo_c4_xdl4_qb0_vbe_node 0 V=v(xdl4.eb0)-v(xdl4.hpn)
Bctle_lo_c4_xdl4_qb0_vce_node ctle_lo_c4_xdl4_qb0_vce_node 0 V=v(xdl4.cb0)-v(xdl4.eb0)
Bctle_lo_c4_xdl4_spa0_vbe_node ctle_lo_c4_xdl4_spa0_vbe_node 0 V=v(xdl4.ca0)-v(l4k0)
Bctle_lo_c4_xdl4_spa0_vce_node ctle_lo_c4_xdl4_spa0_vce_node 0 V=v(onl4)-v(xdl4.ca0)
Bctle_lo_c4_xdl4_sna0_vbe_node ctle_lo_c4_xdl4_sna0_vbe_node 0 V=v(xdl4.ca0)-v(l4k0b)
Bctle_lo_c4_xdl4_sna0_vce_node ctle_lo_c4_xdl4_sna0_vce_node 0 V=v(opl4)-v(xdl4.ca0)
Bctle_lo_c4_xdl4_spb0_vbe_node ctle_lo_c4_xdl4_spb0_vbe_node 0 V=v(xdl4.cb0)-v(l4k0)
Bctle_lo_c4_xdl4_spb0_vce_node ctle_lo_c4_xdl4_spb0_vce_node 0 V=v(opl4)-v(xdl4.cb0)
Bctle_lo_c4_xdl4_snb0_vbe_node ctle_lo_c4_xdl4_snb0_vbe_node 0 V=v(xdl4.cb0)-v(l4k0b)
Bctle_lo_c4_xdl4_snb0_vce_node ctle_lo_c4_xdl4_snb0_vce_node 0 V=v(onl4)-v(xdl4.cb0)
Bctle_lo_c4_xdl4_qa1_vbe_node ctle_lo_c4_xdl4_qa1_vbe_node 0 V=v(xdl4.ea1)-v(xdl4.hpp)
Bctle_lo_c4_xdl4_qa1_vce_node ctle_lo_c4_xdl4_qa1_vce_node 0 V=v(xdl4.ca1)-v(xdl4.ea1)
Bctle_lo_c4_xdl4_qb1_vbe_node ctle_lo_c4_xdl4_qb1_vbe_node 0 V=v(xdl4.eb1)-v(xdl4.hpn)
Bctle_lo_c4_xdl4_qb1_vce_node ctle_lo_c4_xdl4_qb1_vce_node 0 V=v(xdl4.cb1)-v(xdl4.eb1)
Bctle_lo_c4_xdl4_spa1_vbe_node ctle_lo_c4_xdl4_spa1_vbe_node 0 V=v(xdl4.ca1)-v(l4k1)
Bctle_lo_c4_xdl4_spa1_vce_node ctle_lo_c4_xdl4_spa1_vce_node 0 V=v(onl4)-v(xdl4.ca1)
Bctle_lo_c4_xdl4_sna1_vbe_node ctle_lo_c4_xdl4_sna1_vbe_node 0 V=v(xdl4.ca1)-v(l4k1b)
Bctle_lo_c4_xdl4_sna1_vce_node ctle_lo_c4_xdl4_sna1_vce_node 0 V=v(opl4)-v(xdl4.ca1)
Bctle_lo_c4_xdl4_spb1_vbe_node ctle_lo_c4_xdl4_spb1_vbe_node 0 V=v(xdl4.cb1)-v(l4k1)
Bctle_lo_c4_xdl4_spb1_vce_node ctle_lo_c4_xdl4_spb1_vce_node 0 V=v(opl4)-v(xdl4.cb1)
Bctle_lo_c4_xdl4_snb1_vbe_node ctle_lo_c4_xdl4_snb1_vbe_node 0 V=v(xdl4.cb1)-v(l4k1b)
Bctle_lo_c4_xdl4_snb1_vce_node ctle_lo_c4_xdl4_snb1_vce_node 0 V=v(onl4)-v(xdl4.cb1)
Bctle_lo_c4_xdl4_qa2_vbe_node ctle_lo_c4_xdl4_qa2_vbe_node 0 V=v(xdl4.ea2)-v(xdl4.hpp)
Bctle_lo_c4_xdl4_qa2_vce_node ctle_lo_c4_xdl4_qa2_vce_node 0 V=v(xdl4.ca2)-v(xdl4.ea2)
Bctle_lo_c4_xdl4_qb2_vbe_node ctle_lo_c4_xdl4_qb2_vbe_node 0 V=v(xdl4.eb2)-v(xdl4.hpn)
Bctle_lo_c4_xdl4_qb2_vce_node ctle_lo_c4_xdl4_qb2_vce_node 0 V=v(xdl4.cb2)-v(xdl4.eb2)
Bctle_lo_c4_xdl4_spa2_vbe_node ctle_lo_c4_xdl4_spa2_vbe_node 0 V=v(xdl4.ca2)-v(l4k2)
Bctle_lo_c4_xdl4_spa2_vce_node ctle_lo_c4_xdl4_spa2_vce_node 0 V=v(onl4)-v(xdl4.ca2)
Bctle_lo_c4_xdl4_sna2_vbe_node ctle_lo_c4_xdl4_sna2_vbe_node 0 V=v(xdl4.ca2)-v(l4k2b)
Bctle_lo_c4_xdl4_sna2_vce_node ctle_lo_c4_xdl4_sna2_vce_node 0 V=v(opl4)-v(xdl4.ca2)
Bctle_lo_c4_xdl4_spb2_vbe_node ctle_lo_c4_xdl4_spb2_vbe_node 0 V=v(xdl4.cb2)-v(l4k2)
Bctle_lo_c4_xdl4_spb2_vce_node ctle_lo_c4_xdl4_spb2_vce_node 0 V=v(opl4)-v(xdl4.cb2)
Bctle_lo_c4_xdl4_snb2_vbe_node ctle_lo_c4_xdl4_snb2_vbe_node 0 V=v(xdl4.cb2)-v(l4k2b)
Bctle_lo_c4_xdl4_snb2_vce_node ctle_lo_c4_xdl4_snb2_vce_node 0 V=v(onl4)-v(xdl4.cb2)
Bctle_lo_c5_xdl5_q1_vbe_node ctle_lo_c5_xdl5_q1_vbe_node 0 V=v(xdl5.e1)-v(inp)
Bctle_lo_c5_xdl5_q1_vce_node ctle_lo_c5_xdl5_q1_vce_node 0 V=v(onl5)-v(xdl5.e1)
Bctle_lo_c5_xdl5_q2_vbe_node ctle_lo_c5_xdl5_q2_vbe_node 0 V=v(xdl5.e2)-v(inn)
Bctle_lo_c5_xdl5_q2_vce_node ctle_lo_c5_xdl5_q2_vce_node 0 V=v(opl5)-v(xdl5.e2)
Bctle_lo_c5_xdl5_qfa_vbe_node ctle_lo_c5_xdl5_qfa_vbe_node 0 V=v(xdl5.efa)-v(xdl5.hpp)
Bctle_lo_c5_xdl5_qfa_vce_node ctle_lo_c5_xdl5_qfa_vce_node 0 V=v(onl5)-v(xdl5.efa)
Bctle_lo_c5_xdl5_qfb_vbe_node ctle_lo_c5_xdl5_qfb_vbe_node 0 V=v(xdl5.efb)-v(xdl5.hpn)
Bctle_lo_c5_xdl5_qfb_vce_node ctle_lo_c5_xdl5_qfb_vce_node 0 V=v(opl5)-v(xdl5.efb)
Bctle_lo_c5_xdl5_qa0_vbe_node ctle_lo_c5_xdl5_qa0_vbe_node 0 V=v(xdl5.ea0)-v(xdl5.hpp)
Bctle_lo_c5_xdl5_qa0_vce_node ctle_lo_c5_xdl5_qa0_vce_node 0 V=v(xdl5.ca0)-v(xdl5.ea0)
Bctle_lo_c5_xdl5_qb0_vbe_node ctle_lo_c5_xdl5_qb0_vbe_node 0 V=v(xdl5.eb0)-v(xdl5.hpn)
Bctle_lo_c5_xdl5_qb0_vce_node ctle_lo_c5_xdl5_qb0_vce_node 0 V=v(xdl5.cb0)-v(xdl5.eb0)
Bctle_lo_c5_xdl5_spa0_vbe_node ctle_lo_c5_xdl5_spa0_vbe_node 0 V=v(xdl5.ca0)-v(l5k0)
Bctle_lo_c5_xdl5_spa0_vce_node ctle_lo_c5_xdl5_spa0_vce_node 0 V=v(onl5)-v(xdl5.ca0)
Bctle_lo_c5_xdl5_sna0_vbe_node ctle_lo_c5_xdl5_sna0_vbe_node 0 V=v(xdl5.ca0)-v(l5k0b)
Bctle_lo_c5_xdl5_sna0_vce_node ctle_lo_c5_xdl5_sna0_vce_node 0 V=v(opl5)-v(xdl5.ca0)
Bctle_lo_c5_xdl5_spb0_vbe_node ctle_lo_c5_xdl5_spb0_vbe_node 0 V=v(xdl5.cb0)-v(l5k0)
Bctle_lo_c5_xdl5_spb0_vce_node ctle_lo_c5_xdl5_spb0_vce_node 0 V=v(opl5)-v(xdl5.cb0)
Bctle_lo_c5_xdl5_snb0_vbe_node ctle_lo_c5_xdl5_snb0_vbe_node 0 V=v(xdl5.cb0)-v(l5k0b)
Bctle_lo_c5_xdl5_snb0_vce_node ctle_lo_c5_xdl5_snb0_vce_node 0 V=v(onl5)-v(xdl5.cb0)
Bctle_lo_c5_xdl5_qa1_vbe_node ctle_lo_c5_xdl5_qa1_vbe_node 0 V=v(xdl5.ea1)-v(xdl5.hpp)
Bctle_lo_c5_xdl5_qa1_vce_node ctle_lo_c5_xdl5_qa1_vce_node 0 V=v(xdl5.ca1)-v(xdl5.ea1)
Bctle_lo_c5_xdl5_qb1_vbe_node ctle_lo_c5_xdl5_qb1_vbe_node 0 V=v(xdl5.eb1)-v(xdl5.hpn)
Bctle_lo_c5_xdl5_qb1_vce_node ctle_lo_c5_xdl5_qb1_vce_node 0 V=v(xdl5.cb1)-v(xdl5.eb1)
Bctle_lo_c5_xdl5_spa1_vbe_node ctle_lo_c5_xdl5_spa1_vbe_node 0 V=v(xdl5.ca1)-v(l5k1)
Bctle_lo_c5_xdl5_spa1_vce_node ctle_lo_c5_xdl5_spa1_vce_node 0 V=v(onl5)-v(xdl5.ca1)
Bctle_lo_c5_xdl5_sna1_vbe_node ctle_lo_c5_xdl5_sna1_vbe_node 0 V=v(xdl5.ca1)-v(l5k1b)
Bctle_lo_c5_xdl5_sna1_vce_node ctle_lo_c5_xdl5_sna1_vce_node 0 V=v(opl5)-v(xdl5.ca1)
Bctle_lo_c5_xdl5_spb1_vbe_node ctle_lo_c5_xdl5_spb1_vbe_node 0 V=v(xdl5.cb1)-v(l5k1)
Bctle_lo_c5_xdl5_spb1_vce_node ctle_lo_c5_xdl5_spb1_vce_node 0 V=v(opl5)-v(xdl5.cb1)
Bctle_lo_c5_xdl5_snb1_vbe_node ctle_lo_c5_xdl5_snb1_vbe_node 0 V=v(xdl5.cb1)-v(l5k1b)
Bctle_lo_c5_xdl5_snb1_vce_node ctle_lo_c5_xdl5_snb1_vce_node 0 V=v(onl5)-v(xdl5.cb1)
Bctle_lo_c5_xdl5_qa2_vbe_node ctle_lo_c5_xdl5_qa2_vbe_node 0 V=v(xdl5.ea2)-v(xdl5.hpp)
Bctle_lo_c5_xdl5_qa2_vce_node ctle_lo_c5_xdl5_qa2_vce_node 0 V=v(xdl5.ca2)-v(xdl5.ea2)
Bctle_lo_c5_xdl5_qb2_vbe_node ctle_lo_c5_xdl5_qb2_vbe_node 0 V=v(xdl5.eb2)-v(xdl5.hpn)
Bctle_lo_c5_xdl5_qb2_vce_node ctle_lo_c5_xdl5_qb2_vce_node 0 V=v(xdl5.cb2)-v(xdl5.eb2)
Bctle_lo_c5_xdl5_spa2_vbe_node ctle_lo_c5_xdl5_spa2_vbe_node 0 V=v(xdl5.ca2)-v(l5k2)
Bctle_lo_c5_xdl5_spa2_vce_node ctle_lo_c5_xdl5_spa2_vce_node 0 V=v(onl5)-v(xdl5.ca2)
Bctle_lo_c5_xdl5_sna2_vbe_node ctle_lo_c5_xdl5_sna2_vbe_node 0 V=v(xdl5.ca2)-v(l5k2b)
Bctle_lo_c5_xdl5_sna2_vce_node ctle_lo_c5_xdl5_sna2_vce_node 0 V=v(opl5)-v(xdl5.ca2)
Bctle_lo_c5_xdl5_spb2_vbe_node ctle_lo_c5_xdl5_spb2_vbe_node 0 V=v(xdl5.cb2)-v(l5k2)
Bctle_lo_c5_xdl5_spb2_vce_node ctle_lo_c5_xdl5_spb2_vce_node 0 V=v(opl5)-v(xdl5.cb2)
Bctle_lo_c5_xdl5_snb2_vbe_node ctle_lo_c5_xdl5_snb2_vbe_node 0 V=v(xdl5.cb2)-v(l5k2b)
Bctle_lo_c5_xdl5_snb2_vce_node ctle_lo_c5_xdl5_snb2_vce_node 0 V=v(onl5)-v(xdl5.cb2)
Bctle_lo_c6_xdl6_q1_vbe_node ctle_lo_c6_xdl6_q1_vbe_node 0 V=v(xdl6.e1)-v(inp)
Bctle_lo_c6_xdl6_q1_vce_node ctle_lo_c6_xdl6_q1_vce_node 0 V=v(onl6)-v(xdl6.e1)
Bctle_lo_c6_xdl6_q2_vbe_node ctle_lo_c6_xdl6_q2_vbe_node 0 V=v(xdl6.e2)-v(inn)
Bctle_lo_c6_xdl6_q2_vce_node ctle_lo_c6_xdl6_q2_vce_node 0 V=v(opl6)-v(xdl6.e2)
Bctle_lo_c6_xdl6_qfa_vbe_node ctle_lo_c6_xdl6_qfa_vbe_node 0 V=v(xdl6.efa)-v(xdl6.hpp)
Bctle_lo_c6_xdl6_qfa_vce_node ctle_lo_c6_xdl6_qfa_vce_node 0 V=v(onl6)-v(xdl6.efa)
Bctle_lo_c6_xdl6_qfb_vbe_node ctle_lo_c6_xdl6_qfb_vbe_node 0 V=v(xdl6.efb)-v(xdl6.hpn)
Bctle_lo_c6_xdl6_qfb_vce_node ctle_lo_c6_xdl6_qfb_vce_node 0 V=v(opl6)-v(xdl6.efb)
Bctle_lo_c6_xdl6_qa0_vbe_node ctle_lo_c6_xdl6_qa0_vbe_node 0 V=v(xdl6.ea0)-v(xdl6.hpp)
Bctle_lo_c6_xdl6_qa0_vce_node ctle_lo_c6_xdl6_qa0_vce_node 0 V=v(xdl6.ca0)-v(xdl6.ea0)
Bctle_lo_c6_xdl6_qb0_vbe_node ctle_lo_c6_xdl6_qb0_vbe_node 0 V=v(xdl6.eb0)-v(xdl6.hpn)
Bctle_lo_c6_xdl6_qb0_vce_node ctle_lo_c6_xdl6_qb0_vce_node 0 V=v(xdl6.cb0)-v(xdl6.eb0)
Bctle_lo_c6_xdl6_spa0_vbe_node ctle_lo_c6_xdl6_spa0_vbe_node 0 V=v(xdl6.ca0)-v(l6k0)
Bctle_lo_c6_xdl6_spa0_vce_node ctle_lo_c6_xdl6_spa0_vce_node 0 V=v(onl6)-v(xdl6.ca0)
Bctle_lo_c6_xdl6_sna0_vbe_node ctle_lo_c6_xdl6_sna0_vbe_node 0 V=v(xdl6.ca0)-v(l6k0b)
Bctle_lo_c6_xdl6_sna0_vce_node ctle_lo_c6_xdl6_sna0_vce_node 0 V=v(opl6)-v(xdl6.ca0)
Bctle_lo_c6_xdl6_spb0_vbe_node ctle_lo_c6_xdl6_spb0_vbe_node 0 V=v(xdl6.cb0)-v(l6k0)
Bctle_lo_c6_xdl6_spb0_vce_node ctle_lo_c6_xdl6_spb0_vce_node 0 V=v(opl6)-v(xdl6.cb0)
Bctle_lo_c6_xdl6_snb0_vbe_node ctle_lo_c6_xdl6_snb0_vbe_node 0 V=v(xdl6.cb0)-v(l6k0b)
Bctle_lo_c6_xdl6_snb0_vce_node ctle_lo_c6_xdl6_snb0_vce_node 0 V=v(onl6)-v(xdl6.cb0)
Bctle_lo_c6_xdl6_qa1_vbe_node ctle_lo_c6_xdl6_qa1_vbe_node 0 V=v(xdl6.ea1)-v(xdl6.hpp)
Bctle_lo_c6_xdl6_qa1_vce_node ctle_lo_c6_xdl6_qa1_vce_node 0 V=v(xdl6.ca1)-v(xdl6.ea1)
Bctle_lo_c6_xdl6_qb1_vbe_node ctle_lo_c6_xdl6_qb1_vbe_node 0 V=v(xdl6.eb1)-v(xdl6.hpn)
Bctle_lo_c6_xdl6_qb1_vce_node ctle_lo_c6_xdl6_qb1_vce_node 0 V=v(xdl6.cb1)-v(xdl6.eb1)
Bctle_lo_c6_xdl6_spa1_vbe_node ctle_lo_c6_xdl6_spa1_vbe_node 0 V=v(xdl6.ca1)-v(l6k1)
Bctle_lo_c6_xdl6_spa1_vce_node ctle_lo_c6_xdl6_spa1_vce_node 0 V=v(onl6)-v(xdl6.ca1)
Bctle_lo_c6_xdl6_sna1_vbe_node ctle_lo_c6_xdl6_sna1_vbe_node 0 V=v(xdl6.ca1)-v(l6k1b)
Bctle_lo_c6_xdl6_sna1_vce_node ctle_lo_c6_xdl6_sna1_vce_node 0 V=v(opl6)-v(xdl6.ca1)
Bctle_lo_c6_xdl6_spb1_vbe_node ctle_lo_c6_xdl6_spb1_vbe_node 0 V=v(xdl6.cb1)-v(l6k1)
Bctle_lo_c6_xdl6_spb1_vce_node ctle_lo_c6_xdl6_spb1_vce_node 0 V=v(opl6)-v(xdl6.cb1)
Bctle_lo_c6_xdl6_snb1_vbe_node ctle_lo_c6_xdl6_snb1_vbe_node 0 V=v(xdl6.cb1)-v(l6k1b)
Bctle_lo_c6_xdl6_snb1_vce_node ctle_lo_c6_xdl6_snb1_vce_node 0 V=v(onl6)-v(xdl6.cb1)
Bctle_lo_c6_xdl6_qa2_vbe_node ctle_lo_c6_xdl6_qa2_vbe_node 0 V=v(xdl6.ea2)-v(xdl6.hpp)
Bctle_lo_c6_xdl6_qa2_vce_node ctle_lo_c6_xdl6_qa2_vce_node 0 V=v(xdl6.ca2)-v(xdl6.ea2)
Bctle_lo_c6_xdl6_qb2_vbe_node ctle_lo_c6_xdl6_qb2_vbe_node 0 V=v(xdl6.eb2)-v(xdl6.hpn)
Bctle_lo_c6_xdl6_qb2_vce_node ctle_lo_c6_xdl6_qb2_vce_node 0 V=v(xdl6.cb2)-v(xdl6.eb2)
Bctle_lo_c6_xdl6_spa2_vbe_node ctle_lo_c6_xdl6_spa2_vbe_node 0 V=v(xdl6.ca2)-v(l6k2)
Bctle_lo_c6_xdl6_spa2_vce_node ctle_lo_c6_xdl6_spa2_vce_node 0 V=v(onl6)-v(xdl6.ca2)
Bctle_lo_c6_xdl6_sna2_vbe_node ctle_lo_c6_xdl6_sna2_vbe_node 0 V=v(xdl6.ca2)-v(l6k2b)
Bctle_lo_c6_xdl6_sna2_vce_node ctle_lo_c6_xdl6_sna2_vce_node 0 V=v(opl6)-v(xdl6.ca2)
Bctle_lo_c6_xdl6_spb2_vbe_node ctle_lo_c6_xdl6_spb2_vbe_node 0 V=v(xdl6.cb2)-v(l6k2)
Bctle_lo_c6_xdl6_spb2_vce_node ctle_lo_c6_xdl6_spb2_vce_node 0 V=v(opl6)-v(xdl6.cb2)
Bctle_lo_c6_xdl6_snb2_vbe_node ctle_lo_c6_xdl6_snb2_vbe_node 0 V=v(xdl6.cb2)-v(l6k2b)
Bctle_lo_c6_xdl6_snb2_vce_node ctle_lo_c6_xdl6_snb2_vce_node 0 V=v(onl6)-v(xdl6.cb2)
Bctle_lo_c7_xdl7_q1_vbe_node ctle_lo_c7_xdl7_q1_vbe_node 0 V=v(xdl7.e1)-v(inp)
Bctle_lo_c7_xdl7_q1_vce_node ctle_lo_c7_xdl7_q1_vce_node 0 V=v(onl7)-v(xdl7.e1)
Bctle_lo_c7_xdl7_q2_vbe_node ctle_lo_c7_xdl7_q2_vbe_node 0 V=v(xdl7.e2)-v(inn)
Bctle_lo_c7_xdl7_q2_vce_node ctle_lo_c7_xdl7_q2_vce_node 0 V=v(opl7)-v(xdl7.e2)
Bctle_lo_c7_xdl7_qfa_vbe_node ctle_lo_c7_xdl7_qfa_vbe_node 0 V=v(xdl7.efa)-v(xdl7.hpp)
Bctle_lo_c7_xdl7_qfa_vce_node ctle_lo_c7_xdl7_qfa_vce_node 0 V=v(onl7)-v(xdl7.efa)
Bctle_lo_c7_xdl7_qfb_vbe_node ctle_lo_c7_xdl7_qfb_vbe_node 0 V=v(xdl7.efb)-v(xdl7.hpn)
Bctle_lo_c7_xdl7_qfb_vce_node ctle_lo_c7_xdl7_qfb_vce_node 0 V=v(opl7)-v(xdl7.efb)
Bctle_lo_c7_xdl7_qa0_vbe_node ctle_lo_c7_xdl7_qa0_vbe_node 0 V=v(xdl7.ea0)-v(xdl7.hpp)
Bctle_lo_c7_xdl7_qa0_vce_node ctle_lo_c7_xdl7_qa0_vce_node 0 V=v(xdl7.ca0)-v(xdl7.ea0)
Bctle_lo_c7_xdl7_qb0_vbe_node ctle_lo_c7_xdl7_qb0_vbe_node 0 V=v(xdl7.eb0)-v(xdl7.hpn)
Bctle_lo_c7_xdl7_qb0_vce_node ctle_lo_c7_xdl7_qb0_vce_node 0 V=v(xdl7.cb0)-v(xdl7.eb0)
Bctle_lo_c7_xdl7_spa0_vbe_node ctle_lo_c7_xdl7_spa0_vbe_node 0 V=v(xdl7.ca0)-v(l7k0)
Bctle_lo_c7_xdl7_spa0_vce_node ctle_lo_c7_xdl7_spa0_vce_node 0 V=v(onl7)-v(xdl7.ca0)
Bctle_lo_c7_xdl7_sna0_vbe_node ctle_lo_c7_xdl7_sna0_vbe_node 0 V=v(xdl7.ca0)-v(l7k0b)
Bctle_lo_c7_xdl7_sna0_vce_node ctle_lo_c7_xdl7_sna0_vce_node 0 V=v(opl7)-v(xdl7.ca0)
Bctle_lo_c7_xdl7_spb0_vbe_node ctle_lo_c7_xdl7_spb0_vbe_node 0 V=v(xdl7.cb0)-v(l7k0)
Bctle_lo_c7_xdl7_spb0_vce_node ctle_lo_c7_xdl7_spb0_vce_node 0 V=v(opl7)-v(xdl7.cb0)
Bctle_lo_c7_xdl7_snb0_vbe_node ctle_lo_c7_xdl7_snb0_vbe_node 0 V=v(xdl7.cb0)-v(l7k0b)
Bctle_lo_c7_xdl7_snb0_vce_node ctle_lo_c7_xdl7_snb0_vce_node 0 V=v(onl7)-v(xdl7.cb0)
Bctle_lo_c7_xdl7_qa1_vbe_node ctle_lo_c7_xdl7_qa1_vbe_node 0 V=v(xdl7.ea1)-v(xdl7.hpp)
Bctle_lo_c7_xdl7_qa1_vce_node ctle_lo_c7_xdl7_qa1_vce_node 0 V=v(xdl7.ca1)-v(xdl7.ea1)
Bctle_lo_c7_xdl7_qb1_vbe_node ctle_lo_c7_xdl7_qb1_vbe_node 0 V=v(xdl7.eb1)-v(xdl7.hpn)
Bctle_lo_c7_xdl7_qb1_vce_node ctle_lo_c7_xdl7_qb1_vce_node 0 V=v(xdl7.cb1)-v(xdl7.eb1)
Bctle_lo_c7_xdl7_spa1_vbe_node ctle_lo_c7_xdl7_spa1_vbe_node 0 V=v(xdl7.ca1)-v(l7k1)
Bctle_lo_c7_xdl7_spa1_vce_node ctle_lo_c7_xdl7_spa1_vce_node 0 V=v(onl7)-v(xdl7.ca1)
Bctle_lo_c7_xdl7_sna1_vbe_node ctle_lo_c7_xdl7_sna1_vbe_node 0 V=v(xdl7.ca1)-v(l7k1b)
Bctle_lo_c7_xdl7_sna1_vce_node ctle_lo_c7_xdl7_sna1_vce_node 0 V=v(opl7)-v(xdl7.ca1)
Bctle_lo_c7_xdl7_spb1_vbe_node ctle_lo_c7_xdl7_spb1_vbe_node 0 V=v(xdl7.cb1)-v(l7k1)
Bctle_lo_c7_xdl7_spb1_vce_node ctle_lo_c7_xdl7_spb1_vce_node 0 V=v(opl7)-v(xdl7.cb1)
Bctle_lo_c7_xdl7_snb1_vbe_node ctle_lo_c7_xdl7_snb1_vbe_node 0 V=v(xdl7.cb1)-v(l7k1b)
Bctle_lo_c7_xdl7_snb1_vce_node ctle_lo_c7_xdl7_snb1_vce_node 0 V=v(onl7)-v(xdl7.cb1)
Bctle_lo_c7_xdl7_qa2_vbe_node ctle_lo_c7_xdl7_qa2_vbe_node 0 V=v(xdl7.ea2)-v(xdl7.hpp)
Bctle_lo_c7_xdl7_qa2_vce_node ctle_lo_c7_xdl7_qa2_vce_node 0 V=v(xdl7.ca2)-v(xdl7.ea2)
Bctle_lo_c7_xdl7_qb2_vbe_node ctle_lo_c7_xdl7_qb2_vbe_node 0 V=v(xdl7.eb2)-v(xdl7.hpn)
Bctle_lo_c7_xdl7_qb2_vce_node ctle_lo_c7_xdl7_qb2_vce_node 0 V=v(xdl7.cb2)-v(xdl7.eb2)
Bctle_lo_c7_xdl7_spa2_vbe_node ctle_lo_c7_xdl7_spa2_vbe_node 0 V=v(xdl7.ca2)-v(l7k2)
Bctle_lo_c7_xdl7_spa2_vce_node ctle_lo_c7_xdl7_spa2_vce_node 0 V=v(onl7)-v(xdl7.ca2)
Bctle_lo_c7_xdl7_sna2_vbe_node ctle_lo_c7_xdl7_sna2_vbe_node 0 V=v(xdl7.ca2)-v(l7k2b)
Bctle_lo_c7_xdl7_sna2_vce_node ctle_lo_c7_xdl7_sna2_vce_node 0 V=v(opl7)-v(xdl7.ca2)
Bctle_lo_c7_xdl7_spb2_vbe_node ctle_lo_c7_xdl7_spb2_vbe_node 0 V=v(xdl7.cb2)-v(l7k2)
Bctle_lo_c7_xdl7_spb2_vce_node ctle_lo_c7_xdl7_spb2_vce_node 0 V=v(opl7)-v(xdl7.cb2)
Bctle_lo_c7_xdl7_snb2_vbe_node ctle_lo_c7_xdl7_snb2_vbe_node 0 V=v(xdl7.cb2)-v(l7k2b)
Bctle_lo_c7_xdl7_snb2_vce_node ctle_lo_c7_xdl7_snb2_vce_node 0 V=v(onl7)-v(xdl7.cb2)
Bctle_hi_c0_xdh0_q1_vbe_node ctle_hi_c0_xdh0_q1_vbe_node 0 V=v(xdh0.e1)-v(jnp)
Bctle_hi_c0_xdh0_q1_vce_node ctle_hi_c0_xdh0_q1_vce_node 0 V=v(onh0)-v(xdh0.e1)
Bctle_hi_c0_xdh0_q2_vbe_node ctle_hi_c0_xdh0_q2_vbe_node 0 V=v(xdh0.e2)-v(jnn)
Bctle_hi_c0_xdh0_q2_vce_node ctle_hi_c0_xdh0_q2_vce_node 0 V=v(oph0)-v(xdh0.e2)
Bctle_hi_c0_xdh0_qfa_vbe_node ctle_hi_c0_xdh0_qfa_vbe_node 0 V=v(xdh0.efa)-v(xdh0.hpp)
Bctle_hi_c0_xdh0_qfa_vce_node ctle_hi_c0_xdh0_qfa_vce_node 0 V=v(onh0)-v(xdh0.efa)
Bctle_hi_c0_xdh0_qfb_vbe_node ctle_hi_c0_xdh0_qfb_vbe_node 0 V=v(xdh0.efb)-v(xdh0.hpn)
Bctle_hi_c0_xdh0_qfb_vce_node ctle_hi_c0_xdh0_qfb_vce_node 0 V=v(oph0)-v(xdh0.efb)
Bctle_hi_c0_xdh0_qa0_vbe_node ctle_hi_c0_xdh0_qa0_vbe_node 0 V=v(xdh0.ea0)-v(xdh0.hpp)
Bctle_hi_c0_xdh0_qa0_vce_node ctle_hi_c0_xdh0_qa0_vce_node 0 V=v(xdh0.ca0)-v(xdh0.ea0)
Bctle_hi_c0_xdh0_qb0_vbe_node ctle_hi_c0_xdh0_qb0_vbe_node 0 V=v(xdh0.eb0)-v(xdh0.hpn)
Bctle_hi_c0_xdh0_qb0_vce_node ctle_hi_c0_xdh0_qb0_vce_node 0 V=v(xdh0.cb0)-v(xdh0.eb0)
Bctle_hi_c0_xdh0_spa0_vbe_node ctle_hi_c0_xdh0_spa0_vbe_node 0 V=v(xdh0.ca0)-v(h0k0)
Bctle_hi_c0_xdh0_spa0_vce_node ctle_hi_c0_xdh0_spa0_vce_node 0 V=v(onh0)-v(xdh0.ca0)
Bctle_hi_c0_xdh0_sna0_vbe_node ctle_hi_c0_xdh0_sna0_vbe_node 0 V=v(xdh0.ca0)-v(h0k0b)
Bctle_hi_c0_xdh0_sna0_vce_node ctle_hi_c0_xdh0_sna0_vce_node 0 V=v(oph0)-v(xdh0.ca0)
Bctle_hi_c0_xdh0_spb0_vbe_node ctle_hi_c0_xdh0_spb0_vbe_node 0 V=v(xdh0.cb0)-v(h0k0)
Bctle_hi_c0_xdh0_spb0_vce_node ctle_hi_c0_xdh0_spb0_vce_node 0 V=v(oph0)-v(xdh0.cb0)
Bctle_hi_c0_xdh0_snb0_vbe_node ctle_hi_c0_xdh0_snb0_vbe_node 0 V=v(xdh0.cb0)-v(h0k0b)
Bctle_hi_c0_xdh0_snb0_vce_node ctle_hi_c0_xdh0_snb0_vce_node 0 V=v(onh0)-v(xdh0.cb0)
Bctle_hi_c0_xdh0_qa1_vbe_node ctle_hi_c0_xdh0_qa1_vbe_node 0 V=v(xdh0.ea1)-v(xdh0.hpp)
Bctle_hi_c0_xdh0_qa1_vce_node ctle_hi_c0_xdh0_qa1_vce_node 0 V=v(xdh0.ca1)-v(xdh0.ea1)
Bctle_hi_c0_xdh0_qb1_vbe_node ctle_hi_c0_xdh0_qb1_vbe_node 0 V=v(xdh0.eb1)-v(xdh0.hpn)
Bctle_hi_c0_xdh0_qb1_vce_node ctle_hi_c0_xdh0_qb1_vce_node 0 V=v(xdh0.cb1)-v(xdh0.eb1)
Bctle_hi_c0_xdh0_spa1_vbe_node ctle_hi_c0_xdh0_spa1_vbe_node 0 V=v(xdh0.ca1)-v(h0k1)
Bctle_hi_c0_xdh0_spa1_vce_node ctle_hi_c0_xdh0_spa1_vce_node 0 V=v(onh0)-v(xdh0.ca1)
Bctle_hi_c0_xdh0_sna1_vbe_node ctle_hi_c0_xdh0_sna1_vbe_node 0 V=v(xdh0.ca1)-v(h0k1b)
Bctle_hi_c0_xdh0_sna1_vce_node ctle_hi_c0_xdh0_sna1_vce_node 0 V=v(oph0)-v(xdh0.ca1)
Bctle_hi_c0_xdh0_spb1_vbe_node ctle_hi_c0_xdh0_spb1_vbe_node 0 V=v(xdh0.cb1)-v(h0k1)
Bctle_hi_c0_xdh0_spb1_vce_node ctle_hi_c0_xdh0_spb1_vce_node 0 V=v(oph0)-v(xdh0.cb1)
Bctle_hi_c0_xdh0_snb1_vbe_node ctle_hi_c0_xdh0_snb1_vbe_node 0 V=v(xdh0.cb1)-v(h0k1b)
Bctle_hi_c0_xdh0_snb1_vce_node ctle_hi_c0_xdh0_snb1_vce_node 0 V=v(onh0)-v(xdh0.cb1)
Bctle_hi_c0_xdh0_qa2_vbe_node ctle_hi_c0_xdh0_qa2_vbe_node 0 V=v(xdh0.ea2)-v(xdh0.hpp)
Bctle_hi_c0_xdh0_qa2_vce_node ctle_hi_c0_xdh0_qa2_vce_node 0 V=v(xdh0.ca2)-v(xdh0.ea2)
Bctle_hi_c0_xdh0_qb2_vbe_node ctle_hi_c0_xdh0_qb2_vbe_node 0 V=v(xdh0.eb2)-v(xdh0.hpn)
Bctle_hi_c0_xdh0_qb2_vce_node ctle_hi_c0_xdh0_qb2_vce_node 0 V=v(xdh0.cb2)-v(xdh0.eb2)
Bctle_hi_c0_xdh0_spa2_vbe_node ctle_hi_c0_xdh0_spa2_vbe_node 0 V=v(xdh0.ca2)-v(h0k2)
Bctle_hi_c0_xdh0_spa2_vce_node ctle_hi_c0_xdh0_spa2_vce_node 0 V=v(onh0)-v(xdh0.ca2)
Bctle_hi_c0_xdh0_sna2_vbe_node ctle_hi_c0_xdh0_sna2_vbe_node 0 V=v(xdh0.ca2)-v(h0k2b)
Bctle_hi_c0_xdh0_sna2_vce_node ctle_hi_c0_xdh0_sna2_vce_node 0 V=v(oph0)-v(xdh0.ca2)
Bctle_hi_c0_xdh0_spb2_vbe_node ctle_hi_c0_xdh0_spb2_vbe_node 0 V=v(xdh0.cb2)-v(h0k2)
Bctle_hi_c0_xdh0_spb2_vce_node ctle_hi_c0_xdh0_spb2_vce_node 0 V=v(oph0)-v(xdh0.cb2)
Bctle_hi_c0_xdh0_snb2_vbe_node ctle_hi_c0_xdh0_snb2_vbe_node 0 V=v(xdh0.cb2)-v(h0k2b)
Bctle_hi_c0_xdh0_snb2_vce_node ctle_hi_c0_xdh0_snb2_vce_node 0 V=v(onh0)-v(xdh0.cb2)
Bctle_hi_c1_xdh1_q1_vbe_node ctle_hi_c1_xdh1_q1_vbe_node 0 V=v(xdh1.e1)-v(jnp)
Bctle_hi_c1_xdh1_q1_vce_node ctle_hi_c1_xdh1_q1_vce_node 0 V=v(onh1)-v(xdh1.e1)
Bctle_hi_c1_xdh1_q2_vbe_node ctle_hi_c1_xdh1_q2_vbe_node 0 V=v(xdh1.e2)-v(jnn)
Bctle_hi_c1_xdh1_q2_vce_node ctle_hi_c1_xdh1_q2_vce_node 0 V=v(oph1)-v(xdh1.e2)
Bctle_hi_c1_xdh1_qfa_vbe_node ctle_hi_c1_xdh1_qfa_vbe_node 0 V=v(xdh1.efa)-v(xdh1.hpp)
Bctle_hi_c1_xdh1_qfa_vce_node ctle_hi_c1_xdh1_qfa_vce_node 0 V=v(onh1)-v(xdh1.efa)
Bctle_hi_c1_xdh1_qfb_vbe_node ctle_hi_c1_xdh1_qfb_vbe_node 0 V=v(xdh1.efb)-v(xdh1.hpn)
Bctle_hi_c1_xdh1_qfb_vce_node ctle_hi_c1_xdh1_qfb_vce_node 0 V=v(oph1)-v(xdh1.efb)
Bctle_hi_c1_xdh1_qa0_vbe_node ctle_hi_c1_xdh1_qa0_vbe_node 0 V=v(xdh1.ea0)-v(xdh1.hpp)
Bctle_hi_c1_xdh1_qa0_vce_node ctle_hi_c1_xdh1_qa0_vce_node 0 V=v(xdh1.ca0)-v(xdh1.ea0)
Bctle_hi_c1_xdh1_qb0_vbe_node ctle_hi_c1_xdh1_qb0_vbe_node 0 V=v(xdh1.eb0)-v(xdh1.hpn)
Bctle_hi_c1_xdh1_qb0_vce_node ctle_hi_c1_xdh1_qb0_vce_node 0 V=v(xdh1.cb0)-v(xdh1.eb0)
Bctle_hi_c1_xdh1_spa0_vbe_node ctle_hi_c1_xdh1_spa0_vbe_node 0 V=v(xdh1.ca0)-v(h1k0)
Bctle_hi_c1_xdh1_spa0_vce_node ctle_hi_c1_xdh1_spa0_vce_node 0 V=v(onh1)-v(xdh1.ca0)
Bctle_hi_c1_xdh1_sna0_vbe_node ctle_hi_c1_xdh1_sna0_vbe_node 0 V=v(xdh1.ca0)-v(h1k0b)
Bctle_hi_c1_xdh1_sna0_vce_node ctle_hi_c1_xdh1_sna0_vce_node 0 V=v(oph1)-v(xdh1.ca0)
Bctle_hi_c1_xdh1_spb0_vbe_node ctle_hi_c1_xdh1_spb0_vbe_node 0 V=v(xdh1.cb0)-v(h1k0)
Bctle_hi_c1_xdh1_spb0_vce_node ctle_hi_c1_xdh1_spb0_vce_node 0 V=v(oph1)-v(xdh1.cb0)
Bctle_hi_c1_xdh1_snb0_vbe_node ctle_hi_c1_xdh1_snb0_vbe_node 0 V=v(xdh1.cb0)-v(h1k0b)
Bctle_hi_c1_xdh1_snb0_vce_node ctle_hi_c1_xdh1_snb0_vce_node 0 V=v(onh1)-v(xdh1.cb0)
Bctle_hi_c1_xdh1_qa1_vbe_node ctle_hi_c1_xdh1_qa1_vbe_node 0 V=v(xdh1.ea1)-v(xdh1.hpp)
Bctle_hi_c1_xdh1_qa1_vce_node ctle_hi_c1_xdh1_qa1_vce_node 0 V=v(xdh1.ca1)-v(xdh1.ea1)
Bctle_hi_c1_xdh1_qb1_vbe_node ctle_hi_c1_xdh1_qb1_vbe_node 0 V=v(xdh1.eb1)-v(xdh1.hpn)
Bctle_hi_c1_xdh1_qb1_vce_node ctle_hi_c1_xdh1_qb1_vce_node 0 V=v(xdh1.cb1)-v(xdh1.eb1)
Bctle_hi_c1_xdh1_spa1_vbe_node ctle_hi_c1_xdh1_spa1_vbe_node 0 V=v(xdh1.ca1)-v(h1k1)
Bctle_hi_c1_xdh1_spa1_vce_node ctle_hi_c1_xdh1_spa1_vce_node 0 V=v(onh1)-v(xdh1.ca1)
Bctle_hi_c1_xdh1_sna1_vbe_node ctle_hi_c1_xdh1_sna1_vbe_node 0 V=v(xdh1.ca1)-v(h1k1b)
Bctle_hi_c1_xdh1_sna1_vce_node ctle_hi_c1_xdh1_sna1_vce_node 0 V=v(oph1)-v(xdh1.ca1)
Bctle_hi_c1_xdh1_spb1_vbe_node ctle_hi_c1_xdh1_spb1_vbe_node 0 V=v(xdh1.cb1)-v(h1k1)
Bctle_hi_c1_xdh1_spb1_vce_node ctle_hi_c1_xdh1_spb1_vce_node 0 V=v(oph1)-v(xdh1.cb1)
Bctle_hi_c1_xdh1_snb1_vbe_node ctle_hi_c1_xdh1_snb1_vbe_node 0 V=v(xdh1.cb1)-v(h1k1b)
Bctle_hi_c1_xdh1_snb1_vce_node ctle_hi_c1_xdh1_snb1_vce_node 0 V=v(onh1)-v(xdh1.cb1)
Bctle_hi_c1_xdh1_qa2_vbe_node ctle_hi_c1_xdh1_qa2_vbe_node 0 V=v(xdh1.ea2)-v(xdh1.hpp)
Bctle_hi_c1_xdh1_qa2_vce_node ctle_hi_c1_xdh1_qa2_vce_node 0 V=v(xdh1.ca2)-v(xdh1.ea2)
Bctle_hi_c1_xdh1_qb2_vbe_node ctle_hi_c1_xdh1_qb2_vbe_node 0 V=v(xdh1.eb2)-v(xdh1.hpn)
Bctle_hi_c1_xdh1_qb2_vce_node ctle_hi_c1_xdh1_qb2_vce_node 0 V=v(xdh1.cb2)-v(xdh1.eb2)
Bctle_hi_c1_xdh1_spa2_vbe_node ctle_hi_c1_xdh1_spa2_vbe_node 0 V=v(xdh1.ca2)-v(h1k2)
Bctle_hi_c1_xdh1_spa2_vce_node ctle_hi_c1_xdh1_spa2_vce_node 0 V=v(onh1)-v(xdh1.ca2)
Bctle_hi_c1_xdh1_sna2_vbe_node ctle_hi_c1_xdh1_sna2_vbe_node 0 V=v(xdh1.ca2)-v(h1k2b)
Bctle_hi_c1_xdh1_sna2_vce_node ctle_hi_c1_xdh1_sna2_vce_node 0 V=v(oph1)-v(xdh1.ca2)
Bctle_hi_c1_xdh1_spb2_vbe_node ctle_hi_c1_xdh1_spb2_vbe_node 0 V=v(xdh1.cb2)-v(h1k2)
Bctle_hi_c1_xdh1_spb2_vce_node ctle_hi_c1_xdh1_spb2_vce_node 0 V=v(oph1)-v(xdh1.cb2)
Bctle_hi_c1_xdh1_snb2_vbe_node ctle_hi_c1_xdh1_snb2_vbe_node 0 V=v(xdh1.cb2)-v(h1k2b)
Bctle_hi_c1_xdh1_snb2_vce_node ctle_hi_c1_xdh1_snb2_vce_node 0 V=v(onh1)-v(xdh1.cb2)
Bctle_hi_c2_xdh2_q1_vbe_node ctle_hi_c2_xdh2_q1_vbe_node 0 V=v(xdh2.e1)-v(jnp)
Bctle_hi_c2_xdh2_q1_vce_node ctle_hi_c2_xdh2_q1_vce_node 0 V=v(onh2)-v(xdh2.e1)
Bctle_hi_c2_xdh2_q2_vbe_node ctle_hi_c2_xdh2_q2_vbe_node 0 V=v(xdh2.e2)-v(jnn)
Bctle_hi_c2_xdh2_q2_vce_node ctle_hi_c2_xdh2_q2_vce_node 0 V=v(oph2)-v(xdh2.e2)
Bctle_hi_c2_xdh2_qfa_vbe_node ctle_hi_c2_xdh2_qfa_vbe_node 0 V=v(xdh2.efa)-v(xdh2.hpp)
Bctle_hi_c2_xdh2_qfa_vce_node ctle_hi_c2_xdh2_qfa_vce_node 0 V=v(onh2)-v(xdh2.efa)
Bctle_hi_c2_xdh2_qfb_vbe_node ctle_hi_c2_xdh2_qfb_vbe_node 0 V=v(xdh2.efb)-v(xdh2.hpn)
Bctle_hi_c2_xdh2_qfb_vce_node ctle_hi_c2_xdh2_qfb_vce_node 0 V=v(oph2)-v(xdh2.efb)
Bctle_hi_c2_xdh2_qa0_vbe_node ctle_hi_c2_xdh2_qa0_vbe_node 0 V=v(xdh2.ea0)-v(xdh2.hpp)
Bctle_hi_c2_xdh2_qa0_vce_node ctle_hi_c2_xdh2_qa0_vce_node 0 V=v(xdh2.ca0)-v(xdh2.ea0)
Bctle_hi_c2_xdh2_qb0_vbe_node ctle_hi_c2_xdh2_qb0_vbe_node 0 V=v(xdh2.eb0)-v(xdh2.hpn)
Bctle_hi_c2_xdh2_qb0_vce_node ctle_hi_c2_xdh2_qb0_vce_node 0 V=v(xdh2.cb0)-v(xdh2.eb0)
Bctle_hi_c2_xdh2_spa0_vbe_node ctle_hi_c2_xdh2_spa0_vbe_node 0 V=v(xdh2.ca0)-v(h2k0)
Bctle_hi_c2_xdh2_spa0_vce_node ctle_hi_c2_xdh2_spa0_vce_node 0 V=v(onh2)-v(xdh2.ca0)
Bctle_hi_c2_xdh2_sna0_vbe_node ctle_hi_c2_xdh2_sna0_vbe_node 0 V=v(xdh2.ca0)-v(h2k0b)
Bctle_hi_c2_xdh2_sna0_vce_node ctle_hi_c2_xdh2_sna0_vce_node 0 V=v(oph2)-v(xdh2.ca0)
Bctle_hi_c2_xdh2_spb0_vbe_node ctle_hi_c2_xdh2_spb0_vbe_node 0 V=v(xdh2.cb0)-v(h2k0)
Bctle_hi_c2_xdh2_spb0_vce_node ctle_hi_c2_xdh2_spb0_vce_node 0 V=v(oph2)-v(xdh2.cb0)
Bctle_hi_c2_xdh2_snb0_vbe_node ctle_hi_c2_xdh2_snb0_vbe_node 0 V=v(xdh2.cb0)-v(h2k0b)
Bctle_hi_c2_xdh2_snb0_vce_node ctle_hi_c2_xdh2_snb0_vce_node 0 V=v(onh2)-v(xdh2.cb0)
Bctle_hi_c2_xdh2_qa1_vbe_node ctle_hi_c2_xdh2_qa1_vbe_node 0 V=v(xdh2.ea1)-v(xdh2.hpp)
Bctle_hi_c2_xdh2_qa1_vce_node ctle_hi_c2_xdh2_qa1_vce_node 0 V=v(xdh2.ca1)-v(xdh2.ea1)
Bctle_hi_c2_xdh2_qb1_vbe_node ctle_hi_c2_xdh2_qb1_vbe_node 0 V=v(xdh2.eb1)-v(xdh2.hpn)
Bctle_hi_c2_xdh2_qb1_vce_node ctle_hi_c2_xdh2_qb1_vce_node 0 V=v(xdh2.cb1)-v(xdh2.eb1)
Bctle_hi_c2_xdh2_spa1_vbe_node ctle_hi_c2_xdh2_spa1_vbe_node 0 V=v(xdh2.ca1)-v(h2k1)
Bctle_hi_c2_xdh2_spa1_vce_node ctle_hi_c2_xdh2_spa1_vce_node 0 V=v(onh2)-v(xdh2.ca1)
Bctle_hi_c2_xdh2_sna1_vbe_node ctle_hi_c2_xdh2_sna1_vbe_node 0 V=v(xdh2.ca1)-v(h2k1b)
Bctle_hi_c2_xdh2_sna1_vce_node ctle_hi_c2_xdh2_sna1_vce_node 0 V=v(oph2)-v(xdh2.ca1)
Bctle_hi_c2_xdh2_spb1_vbe_node ctle_hi_c2_xdh2_spb1_vbe_node 0 V=v(xdh2.cb1)-v(h2k1)
Bctle_hi_c2_xdh2_spb1_vce_node ctle_hi_c2_xdh2_spb1_vce_node 0 V=v(oph2)-v(xdh2.cb1)
Bctle_hi_c2_xdh2_snb1_vbe_node ctle_hi_c2_xdh2_snb1_vbe_node 0 V=v(xdh2.cb1)-v(h2k1b)
Bctle_hi_c2_xdh2_snb1_vce_node ctle_hi_c2_xdh2_snb1_vce_node 0 V=v(onh2)-v(xdh2.cb1)
Bctle_hi_c2_xdh2_qa2_vbe_node ctle_hi_c2_xdh2_qa2_vbe_node 0 V=v(xdh2.ea2)-v(xdh2.hpp)
Bctle_hi_c2_xdh2_qa2_vce_node ctle_hi_c2_xdh2_qa2_vce_node 0 V=v(xdh2.ca2)-v(xdh2.ea2)
Bctle_hi_c2_xdh2_qb2_vbe_node ctle_hi_c2_xdh2_qb2_vbe_node 0 V=v(xdh2.eb2)-v(xdh2.hpn)
Bctle_hi_c2_xdh2_qb2_vce_node ctle_hi_c2_xdh2_qb2_vce_node 0 V=v(xdh2.cb2)-v(xdh2.eb2)
Bctle_hi_c2_xdh2_spa2_vbe_node ctle_hi_c2_xdh2_spa2_vbe_node 0 V=v(xdh2.ca2)-v(h2k2)
Bctle_hi_c2_xdh2_spa2_vce_node ctle_hi_c2_xdh2_spa2_vce_node 0 V=v(onh2)-v(xdh2.ca2)
Bctle_hi_c2_xdh2_sna2_vbe_node ctle_hi_c2_xdh2_sna2_vbe_node 0 V=v(xdh2.ca2)-v(h2k2b)
Bctle_hi_c2_xdh2_sna2_vce_node ctle_hi_c2_xdh2_sna2_vce_node 0 V=v(oph2)-v(xdh2.ca2)
Bctle_hi_c2_xdh2_spb2_vbe_node ctle_hi_c2_xdh2_spb2_vbe_node 0 V=v(xdh2.cb2)-v(h2k2)
Bctle_hi_c2_xdh2_spb2_vce_node ctle_hi_c2_xdh2_spb2_vce_node 0 V=v(oph2)-v(xdh2.cb2)
Bctle_hi_c2_xdh2_snb2_vbe_node ctle_hi_c2_xdh2_snb2_vbe_node 0 V=v(xdh2.cb2)-v(h2k2b)
Bctle_hi_c2_xdh2_snb2_vce_node ctle_hi_c2_xdh2_snb2_vce_node 0 V=v(onh2)-v(xdh2.cb2)
Bctle_hi_c3_xdh3_q1_vbe_node ctle_hi_c3_xdh3_q1_vbe_node 0 V=v(xdh3.e1)-v(jnp)
Bctle_hi_c3_xdh3_q1_vce_node ctle_hi_c3_xdh3_q1_vce_node 0 V=v(onh3)-v(xdh3.e1)
Bctle_hi_c3_xdh3_q2_vbe_node ctle_hi_c3_xdh3_q2_vbe_node 0 V=v(xdh3.e2)-v(jnn)
Bctle_hi_c3_xdh3_q2_vce_node ctle_hi_c3_xdh3_q2_vce_node 0 V=v(oph3)-v(xdh3.e2)
Bctle_hi_c3_xdh3_qfa_vbe_node ctle_hi_c3_xdh3_qfa_vbe_node 0 V=v(xdh3.efa)-v(xdh3.hpp)
Bctle_hi_c3_xdh3_qfa_vce_node ctle_hi_c3_xdh3_qfa_vce_node 0 V=v(onh3)-v(xdh3.efa)
Bctle_hi_c3_xdh3_qfb_vbe_node ctle_hi_c3_xdh3_qfb_vbe_node 0 V=v(xdh3.efb)-v(xdh3.hpn)
Bctle_hi_c3_xdh3_qfb_vce_node ctle_hi_c3_xdh3_qfb_vce_node 0 V=v(oph3)-v(xdh3.efb)
Bctle_hi_c3_xdh3_qa0_vbe_node ctle_hi_c3_xdh3_qa0_vbe_node 0 V=v(xdh3.ea0)-v(xdh3.hpp)
Bctle_hi_c3_xdh3_qa0_vce_node ctle_hi_c3_xdh3_qa0_vce_node 0 V=v(xdh3.ca0)-v(xdh3.ea0)
Bctle_hi_c3_xdh3_qb0_vbe_node ctle_hi_c3_xdh3_qb0_vbe_node 0 V=v(xdh3.eb0)-v(xdh3.hpn)
Bctle_hi_c3_xdh3_qb0_vce_node ctle_hi_c3_xdh3_qb0_vce_node 0 V=v(xdh3.cb0)-v(xdh3.eb0)
Bctle_hi_c3_xdh3_spa0_vbe_node ctle_hi_c3_xdh3_spa0_vbe_node 0 V=v(xdh3.ca0)-v(h3k0)
Bctle_hi_c3_xdh3_spa0_vce_node ctle_hi_c3_xdh3_spa0_vce_node 0 V=v(onh3)-v(xdh3.ca0)
Bctle_hi_c3_xdh3_sna0_vbe_node ctle_hi_c3_xdh3_sna0_vbe_node 0 V=v(xdh3.ca0)-v(h3k0b)
Bctle_hi_c3_xdh3_sna0_vce_node ctle_hi_c3_xdh3_sna0_vce_node 0 V=v(oph3)-v(xdh3.ca0)
Bctle_hi_c3_xdh3_spb0_vbe_node ctle_hi_c3_xdh3_spb0_vbe_node 0 V=v(xdh3.cb0)-v(h3k0)
Bctle_hi_c3_xdh3_spb0_vce_node ctle_hi_c3_xdh3_spb0_vce_node 0 V=v(oph3)-v(xdh3.cb0)
Bctle_hi_c3_xdh3_snb0_vbe_node ctle_hi_c3_xdh3_snb0_vbe_node 0 V=v(xdh3.cb0)-v(h3k0b)
Bctle_hi_c3_xdh3_snb0_vce_node ctle_hi_c3_xdh3_snb0_vce_node 0 V=v(onh3)-v(xdh3.cb0)
Bctle_hi_c3_xdh3_qa1_vbe_node ctle_hi_c3_xdh3_qa1_vbe_node 0 V=v(xdh3.ea1)-v(xdh3.hpp)
Bctle_hi_c3_xdh3_qa1_vce_node ctle_hi_c3_xdh3_qa1_vce_node 0 V=v(xdh3.ca1)-v(xdh3.ea1)
Bctle_hi_c3_xdh3_qb1_vbe_node ctle_hi_c3_xdh3_qb1_vbe_node 0 V=v(xdh3.eb1)-v(xdh3.hpn)
Bctle_hi_c3_xdh3_qb1_vce_node ctle_hi_c3_xdh3_qb1_vce_node 0 V=v(xdh3.cb1)-v(xdh3.eb1)
Bctle_hi_c3_xdh3_spa1_vbe_node ctle_hi_c3_xdh3_spa1_vbe_node 0 V=v(xdh3.ca1)-v(h3k1)
Bctle_hi_c3_xdh3_spa1_vce_node ctle_hi_c3_xdh3_spa1_vce_node 0 V=v(onh3)-v(xdh3.ca1)
Bctle_hi_c3_xdh3_sna1_vbe_node ctle_hi_c3_xdh3_sna1_vbe_node 0 V=v(xdh3.ca1)-v(h3k1b)
Bctle_hi_c3_xdh3_sna1_vce_node ctle_hi_c3_xdh3_sna1_vce_node 0 V=v(oph3)-v(xdh3.ca1)
Bctle_hi_c3_xdh3_spb1_vbe_node ctle_hi_c3_xdh3_spb1_vbe_node 0 V=v(xdh3.cb1)-v(h3k1)
Bctle_hi_c3_xdh3_spb1_vce_node ctle_hi_c3_xdh3_spb1_vce_node 0 V=v(oph3)-v(xdh3.cb1)
Bctle_hi_c3_xdh3_snb1_vbe_node ctle_hi_c3_xdh3_snb1_vbe_node 0 V=v(xdh3.cb1)-v(h3k1b)
Bctle_hi_c3_xdh3_snb1_vce_node ctle_hi_c3_xdh3_snb1_vce_node 0 V=v(onh3)-v(xdh3.cb1)
Bctle_hi_c3_xdh3_qa2_vbe_node ctle_hi_c3_xdh3_qa2_vbe_node 0 V=v(xdh3.ea2)-v(xdh3.hpp)
Bctle_hi_c3_xdh3_qa2_vce_node ctle_hi_c3_xdh3_qa2_vce_node 0 V=v(xdh3.ca2)-v(xdh3.ea2)
Bctle_hi_c3_xdh3_qb2_vbe_node ctle_hi_c3_xdh3_qb2_vbe_node 0 V=v(xdh3.eb2)-v(xdh3.hpn)
Bctle_hi_c3_xdh3_qb2_vce_node ctle_hi_c3_xdh3_qb2_vce_node 0 V=v(xdh3.cb2)-v(xdh3.eb2)
Bctle_hi_c3_xdh3_spa2_vbe_node ctle_hi_c3_xdh3_spa2_vbe_node 0 V=v(xdh3.ca2)-v(h3k2)
Bctle_hi_c3_xdh3_spa2_vce_node ctle_hi_c3_xdh3_spa2_vce_node 0 V=v(onh3)-v(xdh3.ca2)
Bctle_hi_c3_xdh3_sna2_vbe_node ctle_hi_c3_xdh3_sna2_vbe_node 0 V=v(xdh3.ca2)-v(h3k2b)
Bctle_hi_c3_xdh3_sna2_vce_node ctle_hi_c3_xdh3_sna2_vce_node 0 V=v(oph3)-v(xdh3.ca2)
Bctle_hi_c3_xdh3_spb2_vbe_node ctle_hi_c3_xdh3_spb2_vbe_node 0 V=v(xdh3.cb2)-v(h3k2)
Bctle_hi_c3_xdh3_spb2_vce_node ctle_hi_c3_xdh3_spb2_vce_node 0 V=v(oph3)-v(xdh3.cb2)
Bctle_hi_c3_xdh3_snb2_vbe_node ctle_hi_c3_xdh3_snb2_vbe_node 0 V=v(xdh3.cb2)-v(h3k2b)
Bctle_hi_c3_xdh3_snb2_vce_node ctle_hi_c3_xdh3_snb2_vce_node 0 V=v(onh3)-v(xdh3.cb2)
Bctle_hi_c4_xdh4_q1_vbe_node ctle_hi_c4_xdh4_q1_vbe_node 0 V=v(xdh4.e1)-v(jnp)
Bctle_hi_c4_xdh4_q1_vce_node ctle_hi_c4_xdh4_q1_vce_node 0 V=v(onh4)-v(xdh4.e1)
Bctle_hi_c4_xdh4_q2_vbe_node ctle_hi_c4_xdh4_q2_vbe_node 0 V=v(xdh4.e2)-v(jnn)
Bctle_hi_c4_xdh4_q2_vce_node ctle_hi_c4_xdh4_q2_vce_node 0 V=v(oph4)-v(xdh4.e2)
Bctle_hi_c4_xdh4_qfa_vbe_node ctle_hi_c4_xdh4_qfa_vbe_node 0 V=v(xdh4.efa)-v(xdh4.hpp)
Bctle_hi_c4_xdh4_qfa_vce_node ctle_hi_c4_xdh4_qfa_vce_node 0 V=v(onh4)-v(xdh4.efa)
Bctle_hi_c4_xdh4_qfb_vbe_node ctle_hi_c4_xdh4_qfb_vbe_node 0 V=v(xdh4.efb)-v(xdh4.hpn)
Bctle_hi_c4_xdh4_qfb_vce_node ctle_hi_c4_xdh4_qfb_vce_node 0 V=v(oph4)-v(xdh4.efb)
Bctle_hi_c4_xdh4_qa0_vbe_node ctle_hi_c4_xdh4_qa0_vbe_node 0 V=v(xdh4.ea0)-v(xdh4.hpp)
Bctle_hi_c4_xdh4_qa0_vce_node ctle_hi_c4_xdh4_qa0_vce_node 0 V=v(xdh4.ca0)-v(xdh4.ea0)
Bctle_hi_c4_xdh4_qb0_vbe_node ctle_hi_c4_xdh4_qb0_vbe_node 0 V=v(xdh4.eb0)-v(xdh4.hpn)
Bctle_hi_c4_xdh4_qb0_vce_node ctle_hi_c4_xdh4_qb0_vce_node 0 V=v(xdh4.cb0)-v(xdh4.eb0)
Bctle_hi_c4_xdh4_spa0_vbe_node ctle_hi_c4_xdh4_spa0_vbe_node 0 V=v(xdh4.ca0)-v(h4k0)
Bctle_hi_c4_xdh4_spa0_vce_node ctle_hi_c4_xdh4_spa0_vce_node 0 V=v(onh4)-v(xdh4.ca0)
Bctle_hi_c4_xdh4_sna0_vbe_node ctle_hi_c4_xdh4_sna0_vbe_node 0 V=v(xdh4.ca0)-v(h4k0b)
Bctle_hi_c4_xdh4_sna0_vce_node ctle_hi_c4_xdh4_sna0_vce_node 0 V=v(oph4)-v(xdh4.ca0)
Bctle_hi_c4_xdh4_spb0_vbe_node ctle_hi_c4_xdh4_spb0_vbe_node 0 V=v(xdh4.cb0)-v(h4k0)
Bctle_hi_c4_xdh4_spb0_vce_node ctle_hi_c4_xdh4_spb0_vce_node 0 V=v(oph4)-v(xdh4.cb0)
Bctle_hi_c4_xdh4_snb0_vbe_node ctle_hi_c4_xdh4_snb0_vbe_node 0 V=v(xdh4.cb0)-v(h4k0b)
Bctle_hi_c4_xdh4_snb0_vce_node ctle_hi_c4_xdh4_snb0_vce_node 0 V=v(onh4)-v(xdh4.cb0)
Bctle_hi_c4_xdh4_qa1_vbe_node ctle_hi_c4_xdh4_qa1_vbe_node 0 V=v(xdh4.ea1)-v(xdh4.hpp)
Bctle_hi_c4_xdh4_qa1_vce_node ctle_hi_c4_xdh4_qa1_vce_node 0 V=v(xdh4.ca1)-v(xdh4.ea1)
Bctle_hi_c4_xdh4_qb1_vbe_node ctle_hi_c4_xdh4_qb1_vbe_node 0 V=v(xdh4.eb1)-v(xdh4.hpn)
Bctle_hi_c4_xdh4_qb1_vce_node ctle_hi_c4_xdh4_qb1_vce_node 0 V=v(xdh4.cb1)-v(xdh4.eb1)
Bctle_hi_c4_xdh4_spa1_vbe_node ctle_hi_c4_xdh4_spa1_vbe_node 0 V=v(xdh4.ca1)-v(h4k1)
Bctle_hi_c4_xdh4_spa1_vce_node ctle_hi_c4_xdh4_spa1_vce_node 0 V=v(onh4)-v(xdh4.ca1)
Bctle_hi_c4_xdh4_sna1_vbe_node ctle_hi_c4_xdh4_sna1_vbe_node 0 V=v(xdh4.ca1)-v(h4k1b)
Bctle_hi_c4_xdh4_sna1_vce_node ctle_hi_c4_xdh4_sna1_vce_node 0 V=v(oph4)-v(xdh4.ca1)
Bctle_hi_c4_xdh4_spb1_vbe_node ctle_hi_c4_xdh4_spb1_vbe_node 0 V=v(xdh4.cb1)-v(h4k1)
Bctle_hi_c4_xdh4_spb1_vce_node ctle_hi_c4_xdh4_spb1_vce_node 0 V=v(oph4)-v(xdh4.cb1)
Bctle_hi_c4_xdh4_snb1_vbe_node ctle_hi_c4_xdh4_snb1_vbe_node 0 V=v(xdh4.cb1)-v(h4k1b)
Bctle_hi_c4_xdh4_snb1_vce_node ctle_hi_c4_xdh4_snb1_vce_node 0 V=v(onh4)-v(xdh4.cb1)
Bctle_hi_c4_xdh4_qa2_vbe_node ctle_hi_c4_xdh4_qa2_vbe_node 0 V=v(xdh4.ea2)-v(xdh4.hpp)
Bctle_hi_c4_xdh4_qa2_vce_node ctle_hi_c4_xdh4_qa2_vce_node 0 V=v(xdh4.ca2)-v(xdh4.ea2)
Bctle_hi_c4_xdh4_qb2_vbe_node ctle_hi_c4_xdh4_qb2_vbe_node 0 V=v(xdh4.eb2)-v(xdh4.hpn)
Bctle_hi_c4_xdh4_qb2_vce_node ctle_hi_c4_xdh4_qb2_vce_node 0 V=v(xdh4.cb2)-v(xdh4.eb2)
Bctle_hi_c4_xdh4_spa2_vbe_node ctle_hi_c4_xdh4_spa2_vbe_node 0 V=v(xdh4.ca2)-v(h4k2)
Bctle_hi_c4_xdh4_spa2_vce_node ctle_hi_c4_xdh4_spa2_vce_node 0 V=v(onh4)-v(xdh4.ca2)
Bctle_hi_c4_xdh4_sna2_vbe_node ctle_hi_c4_xdh4_sna2_vbe_node 0 V=v(xdh4.ca2)-v(h4k2b)
Bctle_hi_c4_xdh4_sna2_vce_node ctle_hi_c4_xdh4_sna2_vce_node 0 V=v(oph4)-v(xdh4.ca2)
Bctle_hi_c4_xdh4_spb2_vbe_node ctle_hi_c4_xdh4_spb2_vbe_node 0 V=v(xdh4.cb2)-v(h4k2)
Bctle_hi_c4_xdh4_spb2_vce_node ctle_hi_c4_xdh4_spb2_vce_node 0 V=v(oph4)-v(xdh4.cb2)
Bctle_hi_c4_xdh4_snb2_vbe_node ctle_hi_c4_xdh4_snb2_vbe_node 0 V=v(xdh4.cb2)-v(h4k2b)
Bctle_hi_c4_xdh4_snb2_vce_node ctle_hi_c4_xdh4_snb2_vce_node 0 V=v(onh4)-v(xdh4.cb2)
Bctle_hi_c5_xdh5_q1_vbe_node ctle_hi_c5_xdh5_q1_vbe_node 0 V=v(xdh5.e1)-v(jnp)
Bctle_hi_c5_xdh5_q1_vce_node ctle_hi_c5_xdh5_q1_vce_node 0 V=v(onh5)-v(xdh5.e1)
Bctle_hi_c5_xdh5_q2_vbe_node ctle_hi_c5_xdh5_q2_vbe_node 0 V=v(xdh5.e2)-v(jnn)
Bctle_hi_c5_xdh5_q2_vce_node ctle_hi_c5_xdh5_q2_vce_node 0 V=v(oph5)-v(xdh5.e2)
Bctle_hi_c5_xdh5_qfa_vbe_node ctle_hi_c5_xdh5_qfa_vbe_node 0 V=v(xdh5.efa)-v(xdh5.hpp)
Bctle_hi_c5_xdh5_qfa_vce_node ctle_hi_c5_xdh5_qfa_vce_node 0 V=v(onh5)-v(xdh5.efa)
Bctle_hi_c5_xdh5_qfb_vbe_node ctle_hi_c5_xdh5_qfb_vbe_node 0 V=v(xdh5.efb)-v(xdh5.hpn)
Bctle_hi_c5_xdh5_qfb_vce_node ctle_hi_c5_xdh5_qfb_vce_node 0 V=v(oph5)-v(xdh5.efb)
Bctle_hi_c5_xdh5_qa0_vbe_node ctle_hi_c5_xdh5_qa0_vbe_node 0 V=v(xdh5.ea0)-v(xdh5.hpp)
Bctle_hi_c5_xdh5_qa0_vce_node ctle_hi_c5_xdh5_qa0_vce_node 0 V=v(xdh5.ca0)-v(xdh5.ea0)
Bctle_hi_c5_xdh5_qb0_vbe_node ctle_hi_c5_xdh5_qb0_vbe_node 0 V=v(xdh5.eb0)-v(xdh5.hpn)
Bctle_hi_c5_xdh5_qb0_vce_node ctle_hi_c5_xdh5_qb0_vce_node 0 V=v(xdh5.cb0)-v(xdh5.eb0)
Bctle_hi_c5_xdh5_spa0_vbe_node ctle_hi_c5_xdh5_spa0_vbe_node 0 V=v(xdh5.ca0)-v(h5k0)
Bctle_hi_c5_xdh5_spa0_vce_node ctle_hi_c5_xdh5_spa0_vce_node 0 V=v(onh5)-v(xdh5.ca0)
Bctle_hi_c5_xdh5_sna0_vbe_node ctle_hi_c5_xdh5_sna0_vbe_node 0 V=v(xdh5.ca0)-v(h5k0b)
Bctle_hi_c5_xdh5_sna0_vce_node ctle_hi_c5_xdh5_sna0_vce_node 0 V=v(oph5)-v(xdh5.ca0)
Bctle_hi_c5_xdh5_spb0_vbe_node ctle_hi_c5_xdh5_spb0_vbe_node 0 V=v(xdh5.cb0)-v(h5k0)
Bctle_hi_c5_xdh5_spb0_vce_node ctle_hi_c5_xdh5_spb0_vce_node 0 V=v(oph5)-v(xdh5.cb0)
Bctle_hi_c5_xdh5_snb0_vbe_node ctle_hi_c5_xdh5_snb0_vbe_node 0 V=v(xdh5.cb0)-v(h5k0b)
Bctle_hi_c5_xdh5_snb0_vce_node ctle_hi_c5_xdh5_snb0_vce_node 0 V=v(onh5)-v(xdh5.cb0)
Bctle_hi_c5_xdh5_qa1_vbe_node ctle_hi_c5_xdh5_qa1_vbe_node 0 V=v(xdh5.ea1)-v(xdh5.hpp)
Bctle_hi_c5_xdh5_qa1_vce_node ctle_hi_c5_xdh5_qa1_vce_node 0 V=v(xdh5.ca1)-v(xdh5.ea1)
Bctle_hi_c5_xdh5_qb1_vbe_node ctle_hi_c5_xdh5_qb1_vbe_node 0 V=v(xdh5.eb1)-v(xdh5.hpn)
Bctle_hi_c5_xdh5_qb1_vce_node ctle_hi_c5_xdh5_qb1_vce_node 0 V=v(xdh5.cb1)-v(xdh5.eb1)
Bctle_hi_c5_xdh5_spa1_vbe_node ctle_hi_c5_xdh5_spa1_vbe_node 0 V=v(xdh5.ca1)-v(h5k1)
Bctle_hi_c5_xdh5_spa1_vce_node ctle_hi_c5_xdh5_spa1_vce_node 0 V=v(onh5)-v(xdh5.ca1)
Bctle_hi_c5_xdh5_sna1_vbe_node ctle_hi_c5_xdh5_sna1_vbe_node 0 V=v(xdh5.ca1)-v(h5k1b)
Bctle_hi_c5_xdh5_sna1_vce_node ctle_hi_c5_xdh5_sna1_vce_node 0 V=v(oph5)-v(xdh5.ca1)
Bctle_hi_c5_xdh5_spb1_vbe_node ctle_hi_c5_xdh5_spb1_vbe_node 0 V=v(xdh5.cb1)-v(h5k1)
Bctle_hi_c5_xdh5_spb1_vce_node ctle_hi_c5_xdh5_spb1_vce_node 0 V=v(oph5)-v(xdh5.cb1)
Bctle_hi_c5_xdh5_snb1_vbe_node ctle_hi_c5_xdh5_snb1_vbe_node 0 V=v(xdh5.cb1)-v(h5k1b)
Bctle_hi_c5_xdh5_snb1_vce_node ctle_hi_c5_xdh5_snb1_vce_node 0 V=v(onh5)-v(xdh5.cb1)
Bctle_hi_c5_xdh5_qa2_vbe_node ctle_hi_c5_xdh5_qa2_vbe_node 0 V=v(xdh5.ea2)-v(xdh5.hpp)
Bctle_hi_c5_xdh5_qa2_vce_node ctle_hi_c5_xdh5_qa2_vce_node 0 V=v(xdh5.ca2)-v(xdh5.ea2)
Bctle_hi_c5_xdh5_qb2_vbe_node ctle_hi_c5_xdh5_qb2_vbe_node 0 V=v(xdh5.eb2)-v(xdh5.hpn)
Bctle_hi_c5_xdh5_qb2_vce_node ctle_hi_c5_xdh5_qb2_vce_node 0 V=v(xdh5.cb2)-v(xdh5.eb2)
Bctle_hi_c5_xdh5_spa2_vbe_node ctle_hi_c5_xdh5_spa2_vbe_node 0 V=v(xdh5.ca2)-v(h5k2)
Bctle_hi_c5_xdh5_spa2_vce_node ctle_hi_c5_xdh5_spa2_vce_node 0 V=v(onh5)-v(xdh5.ca2)
Bctle_hi_c5_xdh5_sna2_vbe_node ctle_hi_c5_xdh5_sna2_vbe_node 0 V=v(xdh5.ca2)-v(h5k2b)
Bctle_hi_c5_xdh5_sna2_vce_node ctle_hi_c5_xdh5_sna2_vce_node 0 V=v(oph5)-v(xdh5.ca2)
Bctle_hi_c5_xdh5_spb2_vbe_node ctle_hi_c5_xdh5_spb2_vbe_node 0 V=v(xdh5.cb2)-v(h5k2)
Bctle_hi_c5_xdh5_spb2_vce_node ctle_hi_c5_xdh5_spb2_vce_node 0 V=v(oph5)-v(xdh5.cb2)
Bctle_hi_c5_xdh5_snb2_vbe_node ctle_hi_c5_xdh5_snb2_vbe_node 0 V=v(xdh5.cb2)-v(h5k2b)
Bctle_hi_c5_xdh5_snb2_vce_node ctle_hi_c5_xdh5_snb2_vce_node 0 V=v(onh5)-v(xdh5.cb2)
Bctle_hi_c6_xdh6_q1_vbe_node ctle_hi_c6_xdh6_q1_vbe_node 0 V=v(xdh6.e1)-v(jnp)
Bctle_hi_c6_xdh6_q1_vce_node ctle_hi_c6_xdh6_q1_vce_node 0 V=v(onh6)-v(xdh6.e1)
Bctle_hi_c6_xdh6_q2_vbe_node ctle_hi_c6_xdh6_q2_vbe_node 0 V=v(xdh6.e2)-v(jnn)
Bctle_hi_c6_xdh6_q2_vce_node ctle_hi_c6_xdh6_q2_vce_node 0 V=v(oph6)-v(xdh6.e2)
Bctle_hi_c6_xdh6_qfa_vbe_node ctle_hi_c6_xdh6_qfa_vbe_node 0 V=v(xdh6.efa)-v(xdh6.hpp)
Bctle_hi_c6_xdh6_qfa_vce_node ctle_hi_c6_xdh6_qfa_vce_node 0 V=v(onh6)-v(xdh6.efa)
Bctle_hi_c6_xdh6_qfb_vbe_node ctle_hi_c6_xdh6_qfb_vbe_node 0 V=v(xdh6.efb)-v(xdh6.hpn)
Bctle_hi_c6_xdh6_qfb_vce_node ctle_hi_c6_xdh6_qfb_vce_node 0 V=v(oph6)-v(xdh6.efb)
Bctle_hi_c6_xdh6_qa0_vbe_node ctle_hi_c6_xdh6_qa0_vbe_node 0 V=v(xdh6.ea0)-v(xdh6.hpp)
Bctle_hi_c6_xdh6_qa0_vce_node ctle_hi_c6_xdh6_qa0_vce_node 0 V=v(xdh6.ca0)-v(xdh6.ea0)
Bctle_hi_c6_xdh6_qb0_vbe_node ctle_hi_c6_xdh6_qb0_vbe_node 0 V=v(xdh6.eb0)-v(xdh6.hpn)
Bctle_hi_c6_xdh6_qb0_vce_node ctle_hi_c6_xdh6_qb0_vce_node 0 V=v(xdh6.cb0)-v(xdh6.eb0)
Bctle_hi_c6_xdh6_spa0_vbe_node ctle_hi_c6_xdh6_spa0_vbe_node 0 V=v(xdh6.ca0)-v(h6k0)
Bctle_hi_c6_xdh6_spa0_vce_node ctle_hi_c6_xdh6_spa0_vce_node 0 V=v(onh6)-v(xdh6.ca0)
Bctle_hi_c6_xdh6_sna0_vbe_node ctle_hi_c6_xdh6_sna0_vbe_node 0 V=v(xdh6.ca0)-v(h6k0b)
Bctle_hi_c6_xdh6_sna0_vce_node ctle_hi_c6_xdh6_sna0_vce_node 0 V=v(oph6)-v(xdh6.ca0)
Bctle_hi_c6_xdh6_spb0_vbe_node ctle_hi_c6_xdh6_spb0_vbe_node 0 V=v(xdh6.cb0)-v(h6k0)
Bctle_hi_c6_xdh6_spb0_vce_node ctle_hi_c6_xdh6_spb0_vce_node 0 V=v(oph6)-v(xdh6.cb0)
Bctle_hi_c6_xdh6_snb0_vbe_node ctle_hi_c6_xdh6_snb0_vbe_node 0 V=v(xdh6.cb0)-v(h6k0b)
Bctle_hi_c6_xdh6_snb0_vce_node ctle_hi_c6_xdh6_snb0_vce_node 0 V=v(onh6)-v(xdh6.cb0)
Bctle_hi_c6_xdh6_qa1_vbe_node ctle_hi_c6_xdh6_qa1_vbe_node 0 V=v(xdh6.ea1)-v(xdh6.hpp)
Bctle_hi_c6_xdh6_qa1_vce_node ctle_hi_c6_xdh6_qa1_vce_node 0 V=v(xdh6.ca1)-v(xdh6.ea1)
Bctle_hi_c6_xdh6_qb1_vbe_node ctle_hi_c6_xdh6_qb1_vbe_node 0 V=v(xdh6.eb1)-v(xdh6.hpn)
Bctle_hi_c6_xdh6_qb1_vce_node ctle_hi_c6_xdh6_qb1_vce_node 0 V=v(xdh6.cb1)-v(xdh6.eb1)
Bctle_hi_c6_xdh6_spa1_vbe_node ctle_hi_c6_xdh6_spa1_vbe_node 0 V=v(xdh6.ca1)-v(h6k1)
Bctle_hi_c6_xdh6_spa1_vce_node ctle_hi_c6_xdh6_spa1_vce_node 0 V=v(onh6)-v(xdh6.ca1)
Bctle_hi_c6_xdh6_sna1_vbe_node ctle_hi_c6_xdh6_sna1_vbe_node 0 V=v(xdh6.ca1)-v(h6k1b)
Bctle_hi_c6_xdh6_sna1_vce_node ctle_hi_c6_xdh6_sna1_vce_node 0 V=v(oph6)-v(xdh6.ca1)
Bctle_hi_c6_xdh6_spb1_vbe_node ctle_hi_c6_xdh6_spb1_vbe_node 0 V=v(xdh6.cb1)-v(h6k1)
Bctle_hi_c6_xdh6_spb1_vce_node ctle_hi_c6_xdh6_spb1_vce_node 0 V=v(oph6)-v(xdh6.cb1)
Bctle_hi_c6_xdh6_snb1_vbe_node ctle_hi_c6_xdh6_snb1_vbe_node 0 V=v(xdh6.cb1)-v(h6k1b)
Bctle_hi_c6_xdh6_snb1_vce_node ctle_hi_c6_xdh6_snb1_vce_node 0 V=v(onh6)-v(xdh6.cb1)
Bctle_hi_c6_xdh6_qa2_vbe_node ctle_hi_c6_xdh6_qa2_vbe_node 0 V=v(xdh6.ea2)-v(xdh6.hpp)
Bctle_hi_c6_xdh6_qa2_vce_node ctle_hi_c6_xdh6_qa2_vce_node 0 V=v(xdh6.ca2)-v(xdh6.ea2)
Bctle_hi_c6_xdh6_qb2_vbe_node ctle_hi_c6_xdh6_qb2_vbe_node 0 V=v(xdh6.eb2)-v(xdh6.hpn)
Bctle_hi_c6_xdh6_qb2_vce_node ctle_hi_c6_xdh6_qb2_vce_node 0 V=v(xdh6.cb2)-v(xdh6.eb2)
Bctle_hi_c6_xdh6_spa2_vbe_node ctle_hi_c6_xdh6_spa2_vbe_node 0 V=v(xdh6.ca2)-v(h6k2)
Bctle_hi_c6_xdh6_spa2_vce_node ctle_hi_c6_xdh6_spa2_vce_node 0 V=v(onh6)-v(xdh6.ca2)
Bctle_hi_c6_xdh6_sna2_vbe_node ctle_hi_c6_xdh6_sna2_vbe_node 0 V=v(xdh6.ca2)-v(h6k2b)
Bctle_hi_c6_xdh6_sna2_vce_node ctle_hi_c6_xdh6_sna2_vce_node 0 V=v(oph6)-v(xdh6.ca2)
Bctle_hi_c6_xdh6_spb2_vbe_node ctle_hi_c6_xdh6_spb2_vbe_node 0 V=v(xdh6.cb2)-v(h6k2)
Bctle_hi_c6_xdh6_spb2_vce_node ctle_hi_c6_xdh6_spb2_vce_node 0 V=v(oph6)-v(xdh6.cb2)
Bctle_hi_c6_xdh6_snb2_vbe_node ctle_hi_c6_xdh6_snb2_vbe_node 0 V=v(xdh6.cb2)-v(h6k2b)
Bctle_hi_c6_xdh6_snb2_vce_node ctle_hi_c6_xdh6_snb2_vce_node 0 V=v(onh6)-v(xdh6.cb2)
Bctle_hi_c7_xdh7_q1_vbe_node ctle_hi_c7_xdh7_q1_vbe_node 0 V=v(xdh7.e1)-v(jnp)
Bctle_hi_c7_xdh7_q1_vce_node ctle_hi_c7_xdh7_q1_vce_node 0 V=v(onh7)-v(xdh7.e1)
Bctle_hi_c7_xdh7_q2_vbe_node ctle_hi_c7_xdh7_q2_vbe_node 0 V=v(xdh7.e2)-v(jnn)
Bctle_hi_c7_xdh7_q2_vce_node ctle_hi_c7_xdh7_q2_vce_node 0 V=v(oph7)-v(xdh7.e2)
Bctle_hi_c7_xdh7_qfa_vbe_node ctle_hi_c7_xdh7_qfa_vbe_node 0 V=v(xdh7.efa)-v(xdh7.hpp)
Bctle_hi_c7_xdh7_qfa_vce_node ctle_hi_c7_xdh7_qfa_vce_node 0 V=v(onh7)-v(xdh7.efa)
Bctle_hi_c7_xdh7_qfb_vbe_node ctle_hi_c7_xdh7_qfb_vbe_node 0 V=v(xdh7.efb)-v(xdh7.hpn)
Bctle_hi_c7_xdh7_qfb_vce_node ctle_hi_c7_xdh7_qfb_vce_node 0 V=v(oph7)-v(xdh7.efb)
Bctle_hi_c7_xdh7_qa0_vbe_node ctle_hi_c7_xdh7_qa0_vbe_node 0 V=v(xdh7.ea0)-v(xdh7.hpp)
Bctle_hi_c7_xdh7_qa0_vce_node ctle_hi_c7_xdh7_qa0_vce_node 0 V=v(xdh7.ca0)-v(xdh7.ea0)
Bctle_hi_c7_xdh7_qb0_vbe_node ctle_hi_c7_xdh7_qb0_vbe_node 0 V=v(xdh7.eb0)-v(xdh7.hpn)
Bctle_hi_c7_xdh7_qb0_vce_node ctle_hi_c7_xdh7_qb0_vce_node 0 V=v(xdh7.cb0)-v(xdh7.eb0)
Bctle_hi_c7_xdh7_spa0_vbe_node ctle_hi_c7_xdh7_spa0_vbe_node 0 V=v(xdh7.ca0)-v(h7k0)
Bctle_hi_c7_xdh7_spa0_vce_node ctle_hi_c7_xdh7_spa0_vce_node 0 V=v(onh7)-v(xdh7.ca0)
Bctle_hi_c7_xdh7_sna0_vbe_node ctle_hi_c7_xdh7_sna0_vbe_node 0 V=v(xdh7.ca0)-v(h7k0b)
Bctle_hi_c7_xdh7_sna0_vce_node ctle_hi_c7_xdh7_sna0_vce_node 0 V=v(oph7)-v(xdh7.ca0)
Bctle_hi_c7_xdh7_spb0_vbe_node ctle_hi_c7_xdh7_spb0_vbe_node 0 V=v(xdh7.cb0)-v(h7k0)
Bctle_hi_c7_xdh7_spb0_vce_node ctle_hi_c7_xdh7_spb0_vce_node 0 V=v(oph7)-v(xdh7.cb0)
Bctle_hi_c7_xdh7_snb0_vbe_node ctle_hi_c7_xdh7_snb0_vbe_node 0 V=v(xdh7.cb0)-v(h7k0b)
Bctle_hi_c7_xdh7_snb0_vce_node ctle_hi_c7_xdh7_snb0_vce_node 0 V=v(onh7)-v(xdh7.cb0)
Bctle_hi_c7_xdh7_qa1_vbe_node ctle_hi_c7_xdh7_qa1_vbe_node 0 V=v(xdh7.ea1)-v(xdh7.hpp)
Bctle_hi_c7_xdh7_qa1_vce_node ctle_hi_c7_xdh7_qa1_vce_node 0 V=v(xdh7.ca1)-v(xdh7.ea1)
Bctle_hi_c7_xdh7_qb1_vbe_node ctle_hi_c7_xdh7_qb1_vbe_node 0 V=v(xdh7.eb1)-v(xdh7.hpn)
Bctle_hi_c7_xdh7_qb1_vce_node ctle_hi_c7_xdh7_qb1_vce_node 0 V=v(xdh7.cb1)-v(xdh7.eb1)
Bctle_hi_c7_xdh7_spa1_vbe_node ctle_hi_c7_xdh7_spa1_vbe_node 0 V=v(xdh7.ca1)-v(h7k1)
Bctle_hi_c7_xdh7_spa1_vce_node ctle_hi_c7_xdh7_spa1_vce_node 0 V=v(onh7)-v(xdh7.ca1)
Bctle_hi_c7_xdh7_sna1_vbe_node ctle_hi_c7_xdh7_sna1_vbe_node 0 V=v(xdh7.ca1)-v(h7k1b)
Bctle_hi_c7_xdh7_sna1_vce_node ctle_hi_c7_xdh7_sna1_vce_node 0 V=v(oph7)-v(xdh7.ca1)
Bctle_hi_c7_xdh7_spb1_vbe_node ctle_hi_c7_xdh7_spb1_vbe_node 0 V=v(xdh7.cb1)-v(h7k1)
Bctle_hi_c7_xdh7_spb1_vce_node ctle_hi_c7_xdh7_spb1_vce_node 0 V=v(oph7)-v(xdh7.cb1)
Bctle_hi_c7_xdh7_snb1_vbe_node ctle_hi_c7_xdh7_snb1_vbe_node 0 V=v(xdh7.cb1)-v(h7k1b)
Bctle_hi_c7_xdh7_snb1_vce_node ctle_hi_c7_xdh7_snb1_vce_node 0 V=v(onh7)-v(xdh7.cb1)
Bctle_hi_c7_xdh7_qa2_vbe_node ctle_hi_c7_xdh7_qa2_vbe_node 0 V=v(xdh7.ea2)-v(xdh7.hpp)
Bctle_hi_c7_xdh7_qa2_vce_node ctle_hi_c7_xdh7_qa2_vce_node 0 V=v(xdh7.ca2)-v(xdh7.ea2)
Bctle_hi_c7_xdh7_qb2_vbe_node ctle_hi_c7_xdh7_qb2_vbe_node 0 V=v(xdh7.eb2)-v(xdh7.hpn)
Bctle_hi_c7_xdh7_qb2_vce_node ctle_hi_c7_xdh7_qb2_vce_node 0 V=v(xdh7.cb2)-v(xdh7.eb2)
Bctle_hi_c7_xdh7_spa2_vbe_node ctle_hi_c7_xdh7_spa2_vbe_node 0 V=v(xdh7.ca2)-v(h7k2)
Bctle_hi_c7_xdh7_spa2_vce_node ctle_hi_c7_xdh7_spa2_vce_node 0 V=v(onh7)-v(xdh7.ca2)
Bctle_hi_c7_xdh7_sna2_vbe_node ctle_hi_c7_xdh7_sna2_vbe_node 0 V=v(xdh7.ca2)-v(h7k2b)
Bctle_hi_c7_xdh7_sna2_vce_node ctle_hi_c7_xdh7_sna2_vce_node 0 V=v(oph7)-v(xdh7.ca2)
Bctle_hi_c7_xdh7_spb2_vbe_node ctle_hi_c7_xdh7_spb2_vbe_node 0 V=v(xdh7.cb2)-v(h7k2)
Bctle_hi_c7_xdh7_spb2_vce_node ctle_hi_c7_xdh7_spb2_vce_node 0 V=v(oph7)-v(xdh7.cb2)
Bctle_hi_c7_xdh7_snb2_vbe_node ctle_hi_c7_xdh7_snb2_vbe_node 0 V=v(xdh7.cb2)-v(h7k2b)
Bctle_hi_c7_xdh7_snb2_vce_node ctle_hi_c7_xdh7_snb2_vce_node 0 V=v(onh7)-v(xdh7.cb2)
