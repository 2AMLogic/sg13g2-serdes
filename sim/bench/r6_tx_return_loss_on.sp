* R6 TX return loss bench (issue #92). A BENCH, not a result: no limits, nothing recorded.
* Generated by sim/bench/gen_r6_r20.py; cells inlined from design/tx/netlists/.
* driver ON: bias live, predriver and driver pair balanced at the mux mid level, FFE slices off
* PAD MODEL: the PDK bondpad has no capacitance, so each bondpad is replaced by the EXTRACTED
* pad-metal C (70.66f to ground, record layout/analog/pads/records/2026-11-12-fc8a7fa); the PDK ESD
* diodes come from pad_esd.spice. Quasi-static lumped C: no bondwire/package, no pad coupling.
* rsil is a behavioural stand-in (PDK symbol formula, typical rsh), as in sim/tx/tx_sizing_*.sp.
.subckt rsil 1 2 bn
.param w=0.5e-6 l=0.5e-6 b=0 m=1
R1 1 2 r='(9.0e-6/w + 7.0*l/w)/m' tc1=3.1m
.ends rsil
.subckt bias vdd vss vbn
*.iopin vdd
*.iopin vss
*.iopin vbn
XRref vdd vbn vss rsil w=4u l=114.3u m=1 b=0
XQref vbn vbn er vss npn13G2 Nx=1
XRer er vss vss rsil w=4u l=36.57u m=1 b=0
XCvbn vbn vss cap_cmim w=7u l=7u m=1
.ends

.subckt predriver vdd vss inp inn vbn outp outn
*.iopin vdd
*.iopin vss
*.iopin inp
*.iopin inn
*.iopin vbn
*.iopin outp
*.iopin outn
XQ1 outn inp e vss npn13G2 Nx=4
XQ2 outp inn e vss npn13G2 Nx=4
XQt e vbn et vss npn13G2 Nx=4
XRe et vss vss rsil w=8u l=18.29u m=1 b=0
XRS vdd vl vss rsil w=8u l=11.43u m=1 b=0
XRL1 vl outp vss rsil w=8u l=68.57u m=1 b=0
XRL2 vl outn vss rsil w=8u l=68.57u m=1 b=0
.ends

.subckt driver_ffe vdd vss inp inn pip pin vbn vbp0 vbp1 vbp2 outp outn
*.iopin vdd
*.iopin vss
*.iopin inp
*.iopin inn
*.iopin pip
*.iopin pin
*.iopin vbn
*.iopin vbp0
*.iopin vbp1
*.iopin vbp2
*.iopin outp
*.iopin outn
XQM1 outn inp em vss npn13G2 Nx=8
XQM2 outp inn em vss npn13G2 Nx=8
XQTM em vbn etm vss npn13G2 Nx=8
XREM etm vss vss rsil w=16u l=18.29u m=1 b=0
XRT1 vdd outp vss rsil w=16u l=114.3u m=1 b=0
XRT2 vdd outn vss rsil w=16u l=114.3u m=1 b=0
XQP0a outp pip ep0 vss npn13G2 Nx=1
XQP0b outn pin ep0 vss npn13G2 Nx=1
XQTP0 ep0 vbp0 etp0 vss npn13G2 Nx=1
XREP0 etp0 vss vss rsil w=4u l=41.14u m=1 b=0
XQP1a outp pip ep1 vss npn13G2 Nx=1
XQP1b outn pin ep1 vss npn13G2 Nx=1
XQTP1 ep1 vbp1 etp1 vss npn13G2 Nx=1
XREP1 etp1 vss vss rsil w=4u l=41.14u m=1 b=0
XQP2a outp pip ep2 vss npn13G2 Nx=1
XQP2b outn pin ep2 vss npn13G2 Nx=1
XQTP2 ep2 vbp2 etp2 vss npn13G2 Nx=1
XREP2 etp2 vss vss rsil w=4u l=41.14u m=1 b=0
.ends

.subckt pad_esd vdd vss cp cn padp padn
*.iopin vdd
*.iopin vss
*.iopin cp
*.iopin cn
*.iopin padp
*.iopin padn
XRs0 cp padp vss rsil w=8u l=4.571u m=1 b=0
XDh0 vdd padp vss diodevdd_2kv m=1
XDl0 vdd padp vss diodevss_2kv m=1
CPAD0 padp vss 70.66f
XRs1 cn padn vss rsil w=8u l=4.571u m=1 b=0
XDh1 vdd padn vss diodevdd_2kv m=1
XDl1 vdd padn vss diodevss_2kv m=1
CPAD1 padn vss 70.66f
.ends

Vdd vdd 0 dc 1.2
* mux outputs held at the mid level of the 0.3 V CML swing (balanced pair)
Bmp mp 0 V='v(vdd)-0.15'
Bmn mn 0 V='v(vdd)-0.15'
Bqp qp 0 V='v(vdd)-0.15'
Bqn qn 0 V='v(vdd)-0.15'
Xbias vdd 0 vbn bias
Xprem vdd 0 mp mn vbn pp pn predriver
Xprep vdd 0 qp qn vbn rp rn predriver
Bvbp0 vbp0 0 V=0
Bvbp1 vbp1 0 V=0
Bvbp2 vbp2 0 V=0
Xdrv vdd 0 pp pn rp rn vbn vbp0 vbp1 vbp2 cop con driver_ffe
Xpad vdd 0 cop con padp padn pad_esd
* 100 ohm differential AC port: 2 x 50 ohm, AC-coupled so the driver's DC point is untouched
Vsp sp 0 dc 0 ac 0.5
Vsn sn 0 dc 0 ac -0.5
Rsp sp spc 50
Rsn sn snc 50
Csp spc padp 1u
Csn snc padn 1u
* SDD22 = 2*v(pad diff)/Vs - 1  (Vs = 1 V differential)
Ed a 0 vol='2*(v(padp)-v(padn))'
Vm s a dc 0 ac -1
.ic v(vbn)=0.9
