* R20 clock quality bench (issue #92). A BENCH, not a result: no limits, nothing recorded.
* Generated by sim/bench/gen_r6_r20.py. clk_buf_quad is driven by an IDEAL 5 GHz quadrature
* sine source (common mode 0.8333 vdd, +-150 mV per phase, as sim/rx/latch_regen.sp). This
* is not a clock source design; it isolates the buffer's own duty/quadrature error.
* Load: 20 fF per output (placeholder for the latch clock input, as latch_regen.sp).
.subckt clk_buf_quad ck0 ck180 ck90 ck270 vdd vss b0 b180 b90 b270
*.iopin ck0
*.iopin ck180
*.iopin ck90
*.iopin ck270
*.iopin vdd
*.iopin vss
*.iopin b0
*.iopin b180
*.iopin b90
*.iopin b270
XQi1a min ck0 ti1 vss npn13G2 Nx=2
XQi1b mip ck180 ti1 vss npn13G2 Nx=2
Rti1 ti1 vss 85 m=1
RLi1a vdd min 100 m=1
RLi1b vdd mip 100 m=1
XQi2a b180 min ti2 vss npn13G2 Nx=2
XQi2b b0 mip ti2 vss npn13G2 Nx=2
Rti2 ti2 vss 85 m=1
RLi2a vdd b180 225 m=1
RLi2b vdd b0 225 m=1
XQq1a mqn ck90 tq1 vss npn13G2 Nx=2
XQq1b mqp ck270 tq1 vss npn13G2 Nx=2
Rtq1 tq1 vss 85 m=1
RLq1a vdd mqn 100 m=1
RLq1b vdd mqp 100 m=1
XQq2a b270 mqn tq2 vss npn13G2 Nx=2
XQq2b b90 mqp tq2 vss npn13G2 Nx=2
Rtq2 tq2 vss 85 m=1
RLq2a vdd b270 225 m=1
RLq2b vdd b90 225 m=1
.ends

Vdd vdd 0 1.2
Bck0 ck0 0 V=0.8333*v(vdd)+0.15*sin(2*3.14159265*5e9*time+0*3.14159265/180)
Bck180 ck180 0 V=0.8333*v(vdd)+0.15*sin(2*3.14159265*5e9*time+180*3.14159265/180)
Bck90 ck90 0 V=0.8333*v(vdd)+0.15*sin(2*3.14159265*5e9*time+90*3.14159265/180)
Bck270 ck270 0 V=0.8333*v(vdd)+0.15*sin(2*3.14159265*5e9*time+270*3.14159265/180)
Xclk ck0 ck180 ck90 ck270 vdd 0 b0 b180 b90 b270 clk_buf_quad
Cb0 b0 0 20f
Cb1 b180 0 20f
Cb2 b90 0 20f
Cb3 b270 0 20f
* the two differential pairs the measurements read; pair A = 0/180, pair B = 90/270
Bda da 0 V=v(b0)-v(b180)
Bdb db 0 V=v(b90)-v(b270)
