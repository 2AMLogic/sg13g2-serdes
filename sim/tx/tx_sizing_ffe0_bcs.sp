* TX HBT sizing testbench (issue #21). SIZING EVIDENCE, not a spec result.
* Generated by sim/tx/make_tb.py; cells inlined from design/tx/netlists/.
* Not simulated here (MOS, blocked on #3): mux2to1_cml, ffe_en, lvl_cml2cmos.
* Pad/ESD is a lumped stand-in (4 ohm + 100 fF per leg), not the pad_esd cell.
* Circuit body only: klt sim supplies .lib / .control / .end.
* PDK rsil is an OSDI (r3_cmc) model, which the host ngspice cannot load (#3), so
* rsil is a behavioural stand-in using the PDK symbol's own value formula
* (R = 9e-6/w + 7.0*l/w ohm at b=0, /m) and the model's tc1; rscale carries the
* rsh corner (res_bcs 6.02, res_typ 7.0, res_wcs 7.98 ohm/sq).
.param rscale=0.86
.subckt rsil 1 2 bn
.param w=0.5e-6 l=0.5e-6 b=0 m=1
R1 1 2 r='(9.0e-6/w + 7.0*rscale*l/w)/m' tc1=3.1m
.ends rsil
.subckt bias vdd vss vbn
*.iopin vdd
*.iopin vss
*.iopin vbn
XRref vdd vbn vss rsil w=4u l=114.3u m=1 b=0
XQref vbn vbn er vss npn13G2 Nx=1
XRer er vss vss rsil w=4u l=36.57u m=1 b=0
XCvbn vbn vss cap_cmim w=7u l=7u m=1
.ends

.subckt predriver vdd vss inp inn vbn outp outn
*.iopin vdd
*.iopin vss
*.iopin inp
*.iopin inn
*.iopin vbn
*.iopin outp
*.iopin outn
XQ1 outn inp e vss npn13G2 Nx=4
XQ2 outp inn e vss npn13G2 Nx=4
XQt e vbn et vss npn13G2 Nx=4
XRe et vss vss rsil w=8u l=18.29u m=1 b=0
XRL1 vdd outp vss rsil w=8u l=68.57u m=1 b=0
XRL2 vdd outn vss rsil w=8u l=68.57u m=1 b=0
.ends

.subckt driver_ffe vdd vss inp inn pip pin vbn vbp0 vbp1 vbp2 outp outn
*.iopin vdd
*.iopin vss
*.iopin inp
*.iopin inn
*.iopin pip
*.iopin pin
*.iopin vbn
*.iopin vbp0
*.iopin vbp1
*.iopin vbp2
*.iopin outp
*.iopin outn
XQM1 outn inp em vss npn13G2 Nx=8
XQM2 outp inn em vss npn13G2 Nx=8
XQTM em vbn etm vss npn13G2 Nx=8
XREM etm vss vss rsil w=16u l=18.29u m=1 b=0
XRT1 vdd outp vss rsil w=16u l=114.3u m=1 b=0
XRT2 vdd outn vss rsil w=16u l=114.3u m=1 b=0
XQP0a outp pip ep0 vss npn13G2 Nx=1
XQP0b outn pin ep0 vss npn13G2 Nx=1
XQTP0 ep0 vbp0 etp0 vss npn13G2 Nx=1
XREP0 etp0 vss vss rsil w=4u l=41.14u m=1 b=0
XQP1a outp pip ep1 vss npn13G2 Nx=1
XQP1b outn pin ep1 vss npn13G2 Nx=1
XQTP1 ep1 vbp1 etp1 vss npn13G2 Nx=1
XREP1 etp1 vss vss rsil w=4u l=41.14u m=1 b=0
XQP2a outp pip ep2 vss npn13G2 Nx=1
XQP2b outn pin ep2 vss npn13G2 Nx=1
XQTP2 ep2 vbp2 etp2 vss npn13G2 Nx=1
XREP2 etp2 vss vss rsil w=4u l=41.14u m=1 b=0
.ends

Vdd vdd 0 dc 1.2
Vd d 0 pwl(0 0 2e-10 0 2.2e-10 1 1.4e-09 1 1.42e-09 0 2.6e-09 0 2.62e-09 1 3.8e-09 1 3.82e-09 0 4.4e-09 0 4.42e-09 1 4.5e-09 1 4.52e-09 0 5e-09 0 5.02e-09 1 5.2e-09 1 5.22e-09 0 5.6e-09 0 5.62e-09 1 5.7e-09 1 5.72e-09 0 5.8e-09 0 5.82e-09 1 5.9e-09 1 5.92e-09 0 6.2e-09 0 6.22e-09 1 6.6e-09 1 6.62e-09 0 6.8e-09 0 6.82e-09 1 6.9e-09 1 6.92e-09 0 7.2e-09 0 7.22e-09 1 7.3e-09 1 7.32e-09 0 7.4e-09 0 7.42e-09 1 7.6e-09 1 7.62e-09 0 7.8e-09 0 7.82e-09 1 8.1e-09 1 8.12e-09 0 8.2e-09 0 8.22e-09 1 8.3e-09 1 8.32e-09 0 8.4e-09 0 8.42e-09 1 8.5e-09 1 8.52e-09 0 8.8e-09 0)
Vdd1 dd 0 pwl(0 0 3e-10 0 3.2e-10 1 1.5e-09 1 1.52e-09 0 2.7e-09 0 2.72e-09 1 3.9e-09 1 3.92e-09 0 4.5e-09 0 4.52e-09 1 4.6e-09 1 4.62e-09 0 5.1e-09 0 5.12e-09 1 5.3e-09 1 5.32e-09 0 5.7e-09 0 5.72e-09 1 5.8e-09 1 5.82e-09 0 5.9e-09 0 5.92e-09 1 6e-09 1 6.02e-09 0 6.3e-09 0 6.32e-09 1 6.7e-09 1 6.72e-09 0 6.9e-09 0 6.92e-09 1 7e-09 1 7.02e-09 0 7.3e-09 0 7.32e-09 1 7.4e-09 1 7.42e-09 0 7.5e-09 0 7.52e-09 1 7.7e-09 1 7.72e-09 0 7.9e-09 0 7.92e-09 1 8.2e-09 1 8.22e-09 0 8.3e-09 0 8.32e-09 1 8.4e-09 1 8.42e-09 0 8.5e-09 0 8.52e-09 1 8.6e-09 1 8.62e-09 0 8.8e-09 0)
Bmp mp 0 V='v(vdd)-0.3*(1-v(d))'
Bmn mn 0 V='v(vdd)-0.3*v(d)'
Bqp qp 0 V='v(vdd)-0.3*(1-v(dd))'
Bqn qn 0 V='v(vdd)-0.3*v(dd)'
Xbias vdd 0 vbn bias
Xprem vdd 0 mp mn vbn pp pn predriver
Xprep vdd 0 qp qn vbn rp rn predriver
Bvbp0 vbp0 0 V='ffe*v(vbn)'
Bvbp1 vbp1 0 V='ffe*v(vbn)'
Bvbp2 vbp2 0 V='ffe*v(vbn)'
Xdrv vdd 0 pp pn rp rn vbn vbp0 vbp1 vbp2 cop con driver_ffe
Rpadp cop padp 4
Cpadp padp 0 100f
Rpadn con padn 4
Cpadn padn 0 100f
Rload padp padn 100
Bvd vd 0 V='v(padp)-v(padn)'
.param ffe=0
.ic v(vbn)=0.9
