** sch_path: /home/ubuntu/GitHub/sg13g2-serdes/.loom/worktrees/issue-21/design/tx/tx_top.sch
.subckt tx_top vdd vss ckp ckn dap dan dbp dbn dpap dpan dpbp dpbn en0 en1 en2 ckdp ckdn ckd_cmos padp padn
*.iopin vdd
*.iopin vss
*.iopin ckp
*.iopin ckn
*.iopin dap
*.iopin dan
*.iopin dbp
*.iopin dbn
*.iopin dpap
*.iopin dpan
*.iopin dpbp
*.iopin dpbn
*.iopin en0
*.iopin en1
*.iopin en2
*.iopin ckdp
*.iopin ckdn
*.iopin ckd_cmos
*.iopin padp
*.iopin padn
Xbias vdd vss vbn bias
Xffe_en vdd vss vbn en0 en1 en2 vbp0 vbp1 vbp2 ffe_en
Xmux_main vdd vss ckp ckn dap dan dbp dbn mp mn mux2to1_cml
Xmux_post vdd vss ckp ckn dpap dpan dpbp dpbn qp qn mux2to1_cml
Xpre_main vdd vss mp mn vbn pp pn predriver
Xpre_post vdd vss qp qn vbn rp rn predriver
Xdrv vdd vss pp pn rp rn vbn vbp0 vbp1 vbp2 cp cn driver_ffe
Xpad vdd vss cp cn padp padn pad_esd
Xlvl vdd vss ckdp ckdn ckd_cmos lvl_cml2cmos
.ends

* expanding   symbol:  bias.sym # of pins=3
** sym_path: /home/ubuntu/GitHub/sg13g2-serdes/.loom/worktrees/issue-21/design/tx/bias.sym
** sch_path: /home/ubuntu/GitHub/sg13g2-serdes/.loom/worktrees/issue-21/design/tx/bias.sch
.subckt bias vdd vss vbn
*.iopin vdd
*.iopin vss
*.iopin vbn
XRref vdd vbn vss rsil w=4u l=114.3u m=1 b=0
XQref vbn vbn er vss npn13G2 Nx=1
XRer er vss vss rsil w=4u l=36.57u m=1 b=0
XCvbn vbn vss cap_cmim w=7u l=7u m=1
.ends

* expanding   symbol:  ffe_en.sym # of pins=9
** sym_path: /home/ubuntu/GitHub/sg13g2-serdes/.loom/worktrees/issue-21/design/tx/ffe_en.sym
** sch_path: /home/ubuntu/GitHub/sg13g2-serdes/.loom/worktrees/issue-21/design/tx/ffe_en.sch
.subckt ffe_en vdd vss vbn en0 en1 en2 vbp0 vbp1 vbp2
*.iopin vdd
*.iopin vss
*.iopin vbn
*.iopin en0
*.iopin en1
*.iopin en2
*.iopin vbp0
*.iopin vbp1
*.iopin vbp2
XMPi0 enb0 en0 vdd vdd sg13_lv_pmos w=1u l=0.13u ng=1 m=1
XMNi0 enb0 en0 vss vss sg13_lv_nmos w=0.5u l=0.13u ng=1 m=1
XRb0 vbn vbp0 vss rsil w=2u l=285.7u m=1 b=0
XMNd0 vbp0 enb0 vss vss sg13_lv_nmos w=2u l=0.13u ng=1 m=1
XMPi1 enb1 en1 vdd vdd sg13_lv_pmos w=1u l=0.13u ng=1 m=1
XMNi1 enb1 en1 vss vss sg13_lv_nmos w=0.5u l=0.13u ng=1 m=1
XRb1 vbn vbp1 vss rsil w=2u l=285.7u m=1 b=0
XMNd1 vbp1 enb1 vss vss sg13_lv_nmos w=2u l=0.13u ng=1 m=1
XMPi2 enb2 en2 vdd vdd sg13_lv_pmos w=1u l=0.13u ng=1 m=1
XMNi2 enb2 en2 vss vss sg13_lv_nmos w=0.5u l=0.13u ng=1 m=1
XRb2 vbn vbp2 vss rsil w=2u l=285.7u m=1 b=0
XMNd2 vbp2 enb2 vss vss sg13_lv_nmos w=2u l=0.13u ng=1 m=1
.ends

* expanding   symbol:  mux2to1_cml.sym # of pins=10
** sym_path: /home/ubuntu/GitHub/sg13g2-serdes/.loom/worktrees/issue-21/design/tx/mux2to1_cml.sym
** sch_path: /home/ubuntu/GitHub/sg13g2-serdes/.loom/worktrees/issue-21/design/tx/mux2to1_cml.sch
.subckt mux2to1_cml vdd vss ckp ckn dap dan dbp dbn outp outn
*.iopin vdd
*.iopin vss
*.iopin ckp
*.iopin ckn
*.iopin dap
*.iopin dan
*.iopin dbp
*.iopin dbn
*.iopin outp
*.iopin outn
XCca ckp nca cap_cmim w=7u l=7u m=1
XRfa mida nca vss rppd w=0.5u l=38.46u m=1 b=0
XMP1a mida nca vdd vdd sg13_lv_pmos w=8u l=0.13u ng=2 m=1
XMN1a mida nca vss vss sg13_lv_nmos w=4u l=0.13u ng=2 m=1
XMP2a sqa mida vdd vdd sg13_lv_pmos w=16u l=0.13u ng=4 m=1
XMN2a sqa mida vss vss sg13_lv_nmos w=8u l=0.13u ng=2 m=1
XCcb ckn ncb cap_cmim w=7u l=7u m=1
XRfb midb ncb vss rppd w=0.5u l=38.46u m=1 b=0
XMP1b midb ncb vdd vdd sg13_lv_pmos w=8u l=0.13u ng=2 m=1
XMN1b midb ncb vss vss sg13_lv_nmos w=4u l=0.13u ng=2 m=1
XMP2b sqb midb vdd vdd sg13_lv_pmos w=16u l=0.13u ng=4 m=1
XMN2b sqb midb vss vss sg13_lv_nmos w=8u l=0.13u ng=2 m=1
XQa1 outn dap ea vss npn13G2 Nx=2
XQa2 outp dan ea vss npn13G2 Nx=2
XMTa ea sqa sa vss sg13_lv_nmos w=20u l=0.13u ng=4 m=1
XRsa sa vss vss rsil w=8u l=68.57u m=1 b=0
XQb1 outn dbp eb vss npn13G2 Nx=2
XQb2 outp dbn eb vss npn13G2 Nx=2
XMTb eb sqb sb vss sg13_lv_nmos w=20u l=0.13u ng=4 m=1
XRsb sb vss vss rsil w=8u l=68.57u m=1 b=0
XRLp vdd outp vss rsil w=8u l=114.3u m=1 b=0
XRLn vdd outn vss rsil w=8u l=114.3u m=1 b=0
.ends

* expanding   symbol:  predriver.sym # of pins=7
** sym_path: /home/ubuntu/GitHub/sg13g2-serdes/.loom/worktrees/issue-21/design/tx/predriver.sym
** sch_path: /home/ubuntu/GitHub/sg13g2-serdes/.loom/worktrees/issue-21/design/tx/predriver.sch
.subckt predriver vdd vss inp inn vbn outp outn
*.iopin vdd
*.iopin vss
*.iopin inp
*.iopin inn
*.iopin vbn
*.iopin outp
*.iopin outn
XQ1 outn inp e vss npn13G2 Nx=4
XQ2 outp inn e vss npn13G2 Nx=4
XQt e vbn et vss npn13G2 Nx=4
XRe et vss vss rsil w=8u l=18.29u m=1 b=0
XRL1 vdd outp vss rsil w=8u l=68.57u m=1 b=0
XRL2 vdd outn vss rsil w=8u l=68.57u m=1 b=0
.ends

* expanding   symbol:  driver_ffe.sym # of pins=12
** sym_path: /home/ubuntu/GitHub/sg13g2-serdes/.loom/worktrees/issue-21/design/tx/driver_ffe.sym
** sch_path: /home/ubuntu/GitHub/sg13g2-serdes/.loom/worktrees/issue-21/design/tx/driver_ffe.sch
.subckt driver_ffe vdd vss inp inn pip pin vbn vbp0 vbp1 vbp2 outp outn
*.iopin vdd
*.iopin vss
*.iopin inp
*.iopin inn
*.iopin pip
*.iopin pin
*.iopin vbn
*.iopin vbp0
*.iopin vbp1
*.iopin vbp2
*.iopin outp
*.iopin outn
XQM1 outn inp em vss npn13G2 Nx=8
XQM2 outp inn em vss npn13G2 Nx=8
XQTM em vbn etm vss npn13G2 Nx=8
XREM etm vss vss rsil w=16u l=18.29u m=1 b=0
XRT1 vdd outp vss rsil w=16u l=114.3u m=1 b=0
XRT2 vdd outn vss rsil w=16u l=114.3u m=1 b=0
XQP0a outp pip ep0 vss npn13G2 Nx=1
XQP0b outn pin ep0 vss npn13G2 Nx=1
XQTP0 ep0 vbp0 etp0 vss npn13G2 Nx=1
XREP0 etp0 vss vss rsil w=4u l=41.14u m=1 b=0
XQP1a outp pip ep1 vss npn13G2 Nx=1
XQP1b outn pin ep1 vss npn13G2 Nx=1
XQTP1 ep1 vbp1 etp1 vss npn13G2 Nx=1
XREP1 etp1 vss vss rsil w=4u l=41.14u m=1 b=0
XQP2a outp pip ep2 vss npn13G2 Nx=1
XQP2b outn pin ep2 vss npn13G2 Nx=1
XQTP2 ep2 vbp2 etp2 vss npn13G2 Nx=1
XREP2 etp2 vss vss rsil w=4u l=41.14u m=1 b=0
.ends

* expanding   symbol:  pad_esd.sym # of pins=6
** sym_path: /home/ubuntu/GitHub/sg13g2-serdes/.loom/worktrees/issue-21/design/tx/pad_esd.sym
** sch_path: /home/ubuntu/GitHub/sg13g2-serdes/.loom/worktrees/issue-21/design/tx/pad_esd.sch
.subckt pad_esd vdd vss cp cn padp padn
*.iopin vdd
*.iopin vss
*.iopin cp
*.iopin cn
*.iopin padp
*.iopin padn
XRs0 cp padp vss rsil w=8u l=4.571u m=1 b=0
XDh0 vdd padp vss diodevdd_2kv m=1
XDl0 vdd padp vss diodevss_2kv m=1
XXPAD0 padp bondpad size=80u shape=0 padtype=0
XRs1 cn padn vss rsil w=8u l=4.571u m=1 b=0
XDh1 vdd padn vss diodevdd_2kv m=1
XDl1 vdd padn vss diodevss_2kv m=1
XXPAD1 padn bondpad size=80u shape=0 padtype=0
.ends

* expanding   symbol:  lvl_cml2cmos.sym # of pins=5
** sym_path: /home/ubuntu/GitHub/sg13g2-serdes/.loom/worktrees/issue-21/design/tx/lvl_cml2cmos.sym
** sch_path: /home/ubuntu/GitHub/sg13g2-serdes/.loom/worktrees/issue-21/design/tx/lvl_cml2cmos.sch
.subckt lvl_cml2cmos vdd vss inp inn out
*.iopin vdd
*.iopin vss
*.iopin inp
*.iopin inn
*.iopin out
XMN1 d1 inp s vss sg13_lv_nmos w=8u l=0.13u ng=2 m=1
XMN2 o1 inn s vss sg13_lv_nmos w=8u l=0.13u ng=2 m=1
XMP1 d1 d1 vdd vdd sg13_lv_pmos w=8u l=0.13u ng=2 m=1
XMP2 o1 d1 vdd vdd sg13_lv_pmos w=8u l=0.13u ng=2 m=1
XMNt s vbm vss vss sg13_lv_nmos w=8u l=0.13u ng=2 m=1
XMNb vbm vbm vss vss sg13_lv_nmos w=2u l=0.13u ng=1 m=1
XRbm vdd vbm vss rppd w=0.5u l=19.23u m=1 b=0
XMP3 out o1 vdd vdd sg13_lv_pmos w=4u l=0.13u ng=1 m=1
XMN3 out o1 vss vss sg13_lv_nmos w=2u l=0.13u ng=1 m=1
.ends
