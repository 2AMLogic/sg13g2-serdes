** sch_path: /home/ubuntu/GitHub/sg13g2-serdes/.loom/worktrees/issue-21/design/tx/tx_lvl_cml2cmos.sch
.subckt tx_lvl_cml2cmos vdd vss inp inn out
*.iopin vdd
*.iopin vss
*.iopin inp
*.iopin inn
*.iopin out
XMN1 d1 inp s vss sg13_lv_nmos w=8u l=0.13u ng=2 m=1
XMN2 o1 inn s vss sg13_lv_nmos w=8u l=0.13u ng=2 m=1
XMP1 d1 d1 vdd vdd sg13_lv_pmos w=8u l=0.13u ng=2 m=1
XMP2 o1 d1 vdd vdd sg13_lv_pmos w=8u l=0.13u ng=2 m=1
XMNt s vbm vss vss sg13_lv_nmos w=8u l=0.13u ng=2 m=1
XMNb vbm vbm vss vss sg13_lv_nmos w=2u l=0.13u ng=1 m=1
XRbm vdd vbm vss rppd w=0.5u l=19.23u m=1 b=0
XMP3 out o1 vdd vdd sg13_lv_pmos w=4u l=0.13u ng=1 m=1
XMN3 out o1 vss vss sg13_lv_nmos w=2u l=0.13u ng=1 m=1
.ends
