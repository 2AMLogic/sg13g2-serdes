** sch_path: /home/ubuntu/GitHub/sg13g2-serdes/.loom/worktrees/issue-22/design/rx/lvl_cml2cmos.sch
.subckt lvl_cml2cmos ip in vdd vss op
*.iopin ip
*.iopin in
*.iopin vdd
*.iopin vss
*.iopin op
XMn1 x ip tl vss sg13_lv_nmos w=4u l=0.13u ng=1 m=1
XMn2 y in tl vss sg13_lv_nmos w=4u l=0.13u ng=1 m=1
XMnt tl vdd vss vss sg13_lv_nmos w=2u l=0.5u ng=1 m=1
XMp1 x x vdd vdd sg13_lv_pmos w=4u l=0.13u ng=1 m=1
XMp2 y x vdd vdd sg13_lv_pmos w=4u l=0.13u ng=1 m=1
XMpi1 z y vdd vdd sg13_lv_pmos w=2u l=0.13u ng=1 m=1
XMni1 z y vss vss sg13_lv_nmos w=1u l=0.13u ng=1 m=1
XMpi2 op z vdd vdd sg13_lv_pmos w=4u l=0.13u ng=1 m=1
XMni2 op z vss vss sg13_lv_nmos w=2u l=0.13u ng=1 m=1
.ends
