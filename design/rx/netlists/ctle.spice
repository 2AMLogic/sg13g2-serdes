** sch_path: /home/ubuntu/GitHub/sg13g2-serdes/.loom/worktrees/issue-22/design/rx/ctle.sch
.subckt ctle inp inn vcm vdd vss c0 c0b c1 c1b c2 c2b outp outn
*.iopin inp
*.iopin inn
*.iopin vcm
*.iopin vdd
*.iopin vss
*.iopin c0
*.iopin c0b
*.iopin c1
*.iopin c1b
*.iopin c2
*.iopin c2b
*.iopin outp
*.iopin outn
XQ1 outn inp e1 vss npn13G2 Nx=2
XQ2 outp inn e2 vss npn13G2 Nx=2
Rt1a e1 vss 220 m=1
Rt1b e2 vss 220 m=1
RLa vdd outn 60 m=1
RLb vdd outp 60 m=1
XCca inp hpp cap_cmim w=10u l=10u m=1
XCcb inn hpn cap_cmim w=10u l=10u m=1
Rca hpp vcm 2000 m=1
Rcb hpn vcm 2000 m=1
XQfa outn hpp efa vss npn13G2 Nx=7
XQfb outp hpn efb vss npn13G2 Nx=7
Rfa efa vss 62.86 m=1
Rfb efb vss 62.86 m=1
XQa0 ca0 hpp ea0 vss npn13G2 Nx=1
XQb0 cb0 hpn eb0 vss npn13G2 Nx=1
Ra0 ea0 vss 440 m=1
Rb0 eb0 vss 440 m=1
XSpa0 outn c0 ca0 vss npn13G2 Nx=1
XSna0 outp c0b ca0 vss npn13G2 Nx=1
XSpb0 outp c0 cb0 vss npn13G2 Nx=1
XSnb0 outn c0b cb0 vss npn13G2 Nx=1
XQa1 ca1 hpp ea1 vss npn13G2 Nx=2
XQb1 cb1 hpn eb1 vss npn13G2 Nx=2
Ra1 ea1 vss 220 m=1
Rb1 eb1 vss 220 m=1
XSpa1 outn c1 ca1 vss npn13G2 Nx=2
XSna1 outp c1b ca1 vss npn13G2 Nx=2
XSpb1 outp c1 cb1 vss npn13G2 Nx=2
XSnb1 outn c1b cb1 vss npn13G2 Nx=2
XQa2 ca2 hpp ea2 vss npn13G2 Nx=4
XQb2 cb2 hpn eb2 vss npn13G2 Nx=4
Ra2 ea2 vss 110 m=1
Rb2 eb2 vss 110 m=1
XSpa2 outn c2 ca2 vss npn13G2 Nx=4
XSna2 outp c2b ca2 vss npn13G2 Nx=4
XSpb2 outp c2 cb2 vss npn13G2 Nx=4
XSnb2 outn c2b cb2 vss npn13G2 Nx=4
.ends
